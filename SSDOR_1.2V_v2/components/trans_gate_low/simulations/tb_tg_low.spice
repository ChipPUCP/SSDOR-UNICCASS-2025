** sch_path: /foss/designs/components/trans_gate_low/tb_tg_low.sch
**.subckt tb_tg_low
Vin net2 GND dc 0 sin 0 1 10meg
Vin1 net1 GND dc 0 pulse 0 1 0 1n 1n 1u 2u
V1 net3 GND 0.8
C1 Vout GND 1p m=1
x1 Vout net2 net3 net1 GND trans_gate_low
**** begin user architecture code

** IHP models
.lib cornerMOSlv.lib mos_tt
.lib cornerMOShv.lib mos_tt
.lib cornerHBT.lib hbt_typ
.lib cornerRES.lib res_typ

.tran 100p 10u

**** end user architecture code
**.ends

* expanding   symbol:  trans_gate_low.sym # of pins=5
** sym_path: /foss/designs/components/trans_gate_low/trans_gate_low.sym
** sch_path: /foss/designs/components/trans_gate_low/trans_gate_low.sch
.subckt trans_gate_low OUT IN VDD S VSS
*.ipin S
*.opin OUT
*.ipin IN
*.iopin VDD
*.iopin VSS
XM2 IN net2 OUT OUT sg13_lv_nmos w=5u l=0.13u ng=1 m=100
XM1 OUT net1 IN IN sg13_lv_pmos w=5u l=0.13u ng=1 m=200
x1 VDD S net1 VSS tg_low_noninverbuff
x2 VSS net1 net2 VDD tg_low_inverter
.ends

* expanding   symbol:  tg_low_noninverbuff.sym # of pins=4
** sym_path: /foss/designs/components/trans_gate_low/tg_low_noninverbuff.sym
** sch_path: /foss/designs/components/trans_gate_low/tg_low_noninverbuff.sch
.subckt tg_low_noninverbuff VDD IN OUT VSS
*.iopin VSS
*.iopin VDD
*.ipin IN
*.opin OUT
XM1 net1 IN VDD VDD sg13_lv_pmos w=5u l=0.13u ng=1 m=20
XM2 net1 IN VSS VSS sg13_lv_nmos w=5u l=0.13u ng=1 m=10
XM3 OUT net1 VDD VDD sg13_lv_pmos w=5u l=0.13u ng=1 m=60
XM4 OUT net1 VSS VSS sg13_lv_nmos w=5u l=0.13u ng=1 m=30
.ends

* expanding   symbol:  tg_low_inverter.sym # of pins=4
** sym_path: /foss/designs/components/trans_gate_low/tg_low_inverter.sym
** sch_path: /foss/designs/components/trans_gate_low/tg_low_inverter.sch
.subckt tg_low_inverter VSS IN OUT VDD
*.iopin VSS
*.iopin VDD
*.ipin IN
*.opin OUT
XM1 OUT IN VDD VDD sg13_lv_pmos w=5u l=0.13u ng=1 m=60
XM2 OUT IN VSS VSS sg13_lv_nmos w=5u l=0.13u ng=1 m=30
.ends

.GLOBAL GND
.end
