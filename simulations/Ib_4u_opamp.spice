** sch_path: /foss/designs/SSDOR_w_startup_1V_ihp/Ib_4u/Ib_4u_opamp/Ib_4u_opamp.sch
**.subckt Ib_4u_opamp VDD V+ V- GND Vout
*.iopin VDD
*.ipin V+
*.ipin V-
*.iopin GND
*.opin Vout
XM1 net1 V+ GND GND sg13_lv_nmos w=7.5u l=0.18u ng=2 m=1
XM2 Vout V- GND net2 sg13_lv_nmos w=7.5u l=0.18u ng=2 m=1
XM3 Vout net1 VDD VDD sg13_lv_pmos w=5u l=0.8u ng=1 m=1
XM4 net1 net1 VDD VDD sg13_lv_pmos w=5u l=0.8u ng=1 m=1
**.ends
.end
