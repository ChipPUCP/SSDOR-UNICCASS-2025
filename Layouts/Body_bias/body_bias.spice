** sch_path: /shared/designs/Layouts/Body_bias/body_bias.sch
.subckt body_bias UP DOWN Vb
*.PININFO UP:B DOWN:B Vb:B
M1 Vb DOWN UP net1 sg13_lv_pmos w=9u l=0.13u ng=1 m=1
M2 Vb UP DOWN net1 sg13_lv_pmos w=3u l=0.13u ng=1 m=1
R2 Vb net1 ntap1 A=3.5e-12 P=1.14e-05
.ends
