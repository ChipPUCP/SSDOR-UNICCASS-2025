* Extracted by KLayout with SG13G2 LVS runset on : 15/03/2026 17:47

.SUBCKT cgenerator vss vdd vout
M$1 vdd \$12 \$13 vdd sg13_lv_pmos L=0.13u W=4u AS=1.36p AD=1.36p PS=8.68u
+ PD=8.68u
M$2 vss \$12 \$13 vss sg13_lv_nmos L=0.13u W=2u AS=0.68p AD=0.68p PS=4.68u
+ PD=4.68u
M$3 vout \$13 vdd vdd sg13_lv_pmos L=0.13u W=8u AS=2.12p AD=2.12p PS=13.06u
+ PD=13.06u
M$5 vss \$13 vout vss sg13_lv_nmos L=0.13u W=4u AS=1.06p AD=1.06p PS=7.06u
+ PD=7.06u
M$7 vdd \$12 \$2 vdd sg13_lv_pmos L=1u W=4u AS=1.36p AD=1.36p PS=8.68u PD=8.68u
M$8 vdd \$2 \$3 vdd sg13_lv_pmos L=1u W=4u AS=1.36p AD=1.36p PS=8.68u PD=8.68u
M$9 vdd \$3 \$4 vdd sg13_lv_pmos L=1u W=4u AS=1.36p AD=1.36p PS=8.68u PD=8.68u
M$10 vdd \$4 \$5 vdd sg13_lv_pmos L=1u W=4u AS=1.36p AD=1.36p PS=8.68u PD=8.68u
M$11 vdd \$5 \$6 vdd sg13_lv_pmos L=1u W=4u AS=1.36p AD=1.36p PS=8.68u PD=8.68u
M$12 vdd \$6 \$7 vdd sg13_lv_pmos L=1u W=4u AS=1.36p AD=1.36p PS=8.68u PD=8.68u
M$13 vdd \$7 \$8 vdd sg13_lv_pmos L=1u W=4u AS=1.36p AD=1.36p PS=8.68u PD=8.68u
M$14 vdd \$8 \$9 vdd sg13_lv_pmos L=1u W=4u AS=1.36p AD=1.36p PS=8.68u PD=8.68u
M$15 vdd \$9 \$10 vdd sg13_lv_pmos L=1u W=4u AS=1.36p AD=1.36p PS=8.68u PD=8.68u
M$16 vdd \$10 \$11 vdd sg13_lv_pmos L=1u W=4u AS=1.36p AD=1.36p PS=8.68u
+ PD=8.68u
M$17 vdd \$11 \$12 vdd sg13_lv_pmos L=1u W=4u AS=1.36p AD=1.36p PS=8.68u
+ PD=8.68u
M$18 vss \$12 \$2 vss sg13_lv_nmos L=1u W=2u AS=0.68p AD=0.68p PS=4.68u PD=4.68u
M$19 vss \$8 \$9 vss sg13_lv_nmos L=1u W=2u AS=0.68p AD=0.68p PS=4.68u PD=4.68u
M$20 vss \$9 \$10 vss sg13_lv_nmos L=1u W=2u AS=0.68p AD=0.68p PS=4.68u PD=4.68u
M$21 vss \$7 \$8 vss sg13_lv_nmos L=1u W=2u AS=0.68p AD=0.68p PS=4.68u PD=4.68u
M$22 vss \$6 \$7 vss sg13_lv_nmos L=1u W=2u AS=0.68p AD=0.68p PS=4.68u PD=4.68u
M$23 vss \$10 \$11 vss sg13_lv_nmos L=1u W=2u AS=0.68p AD=0.68p PS=4.68u
+ PD=4.68u
M$24 vss \$5 \$6 vss sg13_lv_nmos L=1u W=2u AS=0.68p AD=0.68p PS=4.68u PD=4.68u
M$25 vss \$4 \$5 vss sg13_lv_nmos L=1u W=2u AS=0.68p AD=0.68p PS=4.68u PD=4.68u
M$26 vss \$11 \$12 vss sg13_lv_nmos L=1u W=2u AS=0.68p AD=0.68p PS=4.68u
+ PD=4.68u
M$27 vss \$3 \$4 vss sg13_lv_nmos L=1u W=2u AS=0.68p AD=0.68p PS=4.68u PD=4.68u
M$28 vss \$2 \$3 vss sg13_lv_nmos L=1u W=2u AS=0.68p AD=0.68p PS=4.68u PD=4.68u
.ENDS cgenerator
