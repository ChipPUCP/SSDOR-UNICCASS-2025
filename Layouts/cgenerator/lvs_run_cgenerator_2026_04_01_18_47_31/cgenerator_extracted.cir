* Extracted by KLayout with SG13G2 LVS runset on : 01/04/2026 18:47

.SUBCKT cgenerator vss vout vdd
R$1 vdd \$16 ntap1 A=29p P=60u
M$2 vdd \$2 \$14 \$16 sg13_lv_pmos L=0.13u W=4u AS=1.36p AD=1.36p PS=8.68u
+ PD=8.68u rfmode=0
M$3 vss \$2 \$14 vss sg13_lv_nmos L=0.13u W=2u AS=0.68p AD=0.68p PS=4.68u
+ PD=4.68u rfmode=0
M$4 vout \$14 vdd \$16 sg13_lv_pmos L=0.13u W=8u AS=2.12p AD=2.12p PS=13.06u
+ PD=13.06u rfmode=0
M$6 vss \$14 vout vss sg13_lv_nmos L=0.13u W=4u AS=1.06p AD=1.06p PS=7.06u
+ PD=7.06u rfmode=0
M$8 vdd \$2 \$3 \$16 sg13_lv_pmos L=1u W=4u AS=1.36p AD=1.36p PS=8.68u PD=8.68u
+ rfmode=0
M$9 vdd \$3 \$4 \$16 sg13_lv_pmos L=1u W=4u AS=1.36p AD=1.36p PS=8.68u PD=8.68u
+ rfmode=0
M$10 vdd \$4 \$5 \$16 sg13_lv_pmos L=1u W=4u AS=1.36p AD=1.36p PS=8.68u
+ PD=8.68u rfmode=0
M$11 vdd \$5 \$6 \$16 sg13_lv_pmos L=1u W=4u AS=1.36p AD=1.36p PS=8.68u
+ PD=8.68u rfmode=0
M$12 vdd \$6 \$7 \$16 sg13_lv_pmos L=1u W=4u AS=1.36p AD=1.36p PS=8.68u
+ PD=8.68u rfmode=0
M$13 vdd \$7 \$8 \$16 sg13_lv_pmos L=1u W=4u AS=1.36p AD=1.36p PS=8.68u
+ PD=8.68u rfmode=0
M$14 vdd \$8 \$9 \$16 sg13_lv_pmos L=1u W=4u AS=1.36p AD=1.36p PS=8.68u
+ PD=8.68u rfmode=0
M$15 vdd \$9 \$10 \$16 sg13_lv_pmos L=1u W=4u AS=1.36p AD=1.36p PS=8.68u
+ PD=8.68u rfmode=0
M$16 vdd \$10 \$11 \$16 sg13_lv_pmos L=1u W=4u AS=1.36p AD=1.36p PS=8.68u
+ PD=8.68u rfmode=0
M$17 vdd \$11 \$12 \$16 sg13_lv_pmos L=1u W=4u AS=1.36p AD=1.36p PS=8.68u
+ PD=8.68u rfmode=0
M$18 vdd \$12 \$2 \$16 sg13_lv_pmos L=1u W=4u AS=1.36p AD=1.36p PS=8.68u
+ PD=8.68u rfmode=0
M$19 vss \$2 \$3 vss sg13_lv_nmos L=1u W=2u AS=0.68p AD=0.68p PS=4.68u PD=4.68u
+ rfmode=0
M$20 vss \$9 \$10 vss sg13_lv_nmos L=1u W=2u AS=0.68p AD=0.68p PS=4.68u
+ PD=4.68u rfmode=0
M$21 vss \$10 \$11 vss sg13_lv_nmos L=1u W=2u AS=0.68p AD=0.68p PS=4.68u
+ PD=4.68u rfmode=0
M$22 vss \$8 \$9 vss sg13_lv_nmos L=1u W=2u AS=0.68p AD=0.68p PS=4.68u PD=4.68u
+ rfmode=0
M$23 vss \$7 \$8 vss sg13_lv_nmos L=1u W=2u AS=0.68p AD=0.68p PS=4.68u PD=4.68u
+ rfmode=0
M$24 vss \$11 \$12 vss sg13_lv_nmos L=1u W=2u AS=0.68p AD=0.68p PS=4.68u
+ PD=4.68u rfmode=0
M$25 vss \$6 \$7 vss sg13_lv_nmos L=1u W=2u AS=0.68p AD=0.68p PS=4.68u PD=4.68u
+ rfmode=0
M$26 vss \$5 \$6 vss sg13_lv_nmos L=1u W=2u AS=0.68p AD=0.68p PS=4.68u PD=4.68u
+ rfmode=0
M$27 vss \$12 \$2 vss sg13_lv_nmos L=1u W=2u AS=0.68p AD=0.68p PS=4.68u
+ PD=4.68u rfmode=0
M$28 vss \$4 \$5 vss sg13_lv_nmos L=1u W=2u AS=0.68p AD=0.68p PS=4.68u PD=4.68u
+ rfmode=0
M$29 vss \$3 \$4 vss sg13_lv_nmos L=1u W=2u AS=0.68p AD=0.68p PS=4.68u PD=4.68u
+ rfmode=0
.ENDS cgenerator
