* Extracted by KLayout with SG13G2 LVS runset on : 30/03/2026 04:01

.SUBCKT ctat_ptat_up_mirror
X$1 \$6 GND \$1 rhigh
X$2 GND \$1 via_stack$20
X$3 \$4 GND \$1 rppd$1
X$4 \$6 \$3 \$1 rppd
X$5 \$1 GND ptap1
X$6 GND \$1 via_stack
X$7 GND \$1 via_stack$17
X$8 GND \$1 via_stack$1
X$9 \$69 \$1 via_stack$19
X$10 \$57 \$1 via_stack$9
X$11 \$57 \$1 via_stack$7
X$12 \$57 \$1 via_stack$8
X$13 \$58 \$1 via_stack$16
X$14 \$75 \$1 via_stack$6
X$15 GND \$143 \$1 \$70 nmos
X$16 \$70 \$1 via_stack$14
X$17 VDD \$1 via_stack$11
X$18 VDD \$75 \$73 \$1 \$143 pmos$1
X$19 \$73 VDD \$1 ntap1$1
X$20 \$94 \$1 via_stack$18
X$21 \$81 \$1 via_stack$5
X$22 \$81 \$1 via_stack$10
X$23 VDD Iref \$237 \$1 \$243 pmos
X$24 VDD \$68 \$1 ntap1$2
X$25 VDD \$1 via_stack$4
X$26 VDD \$237 \$1 ntap1
X$27 VDD \$237 \$1 ntap1
X$28 VDD \$1 via_stack$4
X$29 Iref VDD \$237 \$1 \$81 pmos
X$30 Iref VDD \$237 \$1 \$81 pmos
X$31 Iref VDD \$237 \$1 \$243 pmos
X$32 VDD Iref \$237 \$1 \$243 pmos
X$33 VDD Iref \$237 \$1 \$81 pmos
X$34 VDD Iref \$237 \$1 \$243 pmos
X$35 VDD Iref \$237 \$1 \$243 pmos
X$36 VDD \$94 \$237 \$1 \$81 pmos
X$37 \$70 VDD \$237 \$1 \$81 pmos
X$38 VDD VDD \$237 \$1 VDD pmos
X$39 VDD \$85 \$237 \$1 \$81 pmos
X$40 Iref VDD \$237 \$1 \$81 pmos
X$41 VDD \$123 \$237 \$1 \$81 pmos
X$42 \$88 VDD \$237 \$1 \$81 pmos
X$43 Iref VDD \$237 \$1 \$243 pmos
X$44 Iref VDD \$237 \$1 \$81 pmos
X$45 VDD Iref \$237 \$1 \$81 pmos
X$46 \$88 \$1 via_stack$10
X$47 Iref \$1 via_stack$10
X$48 \$243 \$1 via_stack$5
X$49 \$81 \$1 via_stack$5
X$50 \$81 \$1 via_stack$5
X$51 \$81 \$1 via_stack$5
X$52 \$81 \$1 via_stack$5
X$53 \$81 \$1 via_stack$5
X$54 \$243 \$1 via_stack$5
X$55 \$123 \$1 via_stack$18
X$56 \$79 VDD \$1 ntap1$1
X$57 VDD \$147 \$79 \$1 \$147 pmos$1
X$58 VDD \$81 \$79 \$1 \$147 pmos$1
X$59 \$81 VDD \$79 \$1 \$147 pmos$1
X$60 VDD \$81 \$79 \$1 \$147 pmos$1
X$61 VDD \$147 \$79 \$1 \$147 pmos$1
X$62 \$81 VDD \$79 \$1 \$147 pmos$1
X$63 \$147 VDD \$79 \$1 \$147 pmos$1
X$64 \$147 VDD \$79 \$1 \$147 pmos$1
X$65 VDD \$143 \$73 \$1 \$143 pmos$1
X$66 \$75 VDD \$73 \$1 \$143 pmos$1
X$67 \$143 VDD \$73 \$1 \$143 pmos$1
X$68 VDD \$143 \$73 \$1 \$143 pmos$1
X$69 \$143 VDD \$73 \$1 \$143 pmos$1
X$70 \$75 VDD \$73 \$1 \$143 pmos$1
X$71 VDD \$75 \$73 \$1 \$143 pmos$1
X$72 \$81 \$1 via_stack$11
X$73 VDD \$1 via_stack$11
X$74 VDD \$1 via_stack$11
X$75 VDD \$1 via_stack$11
X$76 \$75 \$1 via_stack$11
X$77 \$75 \$1 via_stack$11
X$78 \$81 \$1 via_stack$11
X$79 VDD \$1 via_stack$11
X$80 \$75 \$1 via_stack$11
X$81 VDD \$1 via_stack$11
X$82 \$81 \$1 via_stack$11
X$83 \$75 \$1 via_stack$11
X$84 \$81 \$1 via_stack$11
X$85 VDD \$1 via_stack$11
X$86 VDD \$1 via_stack$11
X$87 \$85 \$1 via_stack$14
X$88 \$85 \$1 via_stack$14
X$89 \$85 \$1 via_stack$14
X$90 \$70 \$1 via_stack$14
X$91 \$70 \$1 via_stack$14
X$92 \$81 GND \$1 \$58 nmos
X$93 \$81 GND \$1 \$58 nmos
X$94 GND \$147 \$1 \$85 nmos
X$95 \$81 GND \$1 \$58 nmos
X$96 GND \$147 \$1 \$85 nmos
X$97 GND \$81 \$1 \$58 nmos
X$98 \$147 GND \$1 \$85 nmos
X$99 \$81 GND \$1 \$58 nmos
X$100 GND \$147 \$1 \$85 nmos
X$101 GND \$81 \$1 \$58 nmos
X$102 \$147 GND \$1 \$85 nmos
X$103 GND \$147 \$1 \$85 nmos
X$104 \$81 GND \$1 \$57 nmos
X$105 GND \$81 \$1 \$57 nmos
X$106 \$81 GND \$1 \$57 nmos
X$107 GND \$143 \$1 \$70 nmos
X$108 GND \$143 \$1 \$70 nmos
X$109 \$81 GND \$1 \$57 nmos
X$110 \$81 GND \$1 \$57 nmos
X$111 GND \$81 \$1 \$57 nmos
X$112 \$143 GND \$1 \$70 nmos
X$113 GND \$143 \$1 \$70 nmos
X$114 \$143 GND \$1 \$70 nmos
X$115 VDD \$1 via_stack$6
X$116 \$81 \$1 via_stack$6
X$117 \$81 \$1 via_stack$6
X$118 \$81 \$1 via_stack$6
X$119 \$81 \$1 via_stack$6
X$120 \$81 \$1 via_stack$6
X$121 \$81 \$1 via_stack$6
X$122 \$75 \$1 via_stack$6
X$123 VDD \$1 via_stack$6
X$124 \$94 \$1 via_stack$6
X$125 \$94 \$1 via_stack$6
X$126 \$94 \$1 via_stack$6
X$127 \$75 \$1 via_stack$6
X$128 \$123 \$1 via_stack$6
X$129 \$147 \$1 via_stack$8
X$130 \$58 \$1 via_stack$8
X$131 \$147 \$1 via_stack$8
X$132 \$58 \$1 via_stack$8
X$133 \$58 \$1 via_stack$8
X$134 \$58 \$1 via_stack$8
X$135 \$143 \$1 via_stack$8
X$136 \$143 \$1 via_stack$8
X$137 \$57 \$1 via_stack$8
X$138 \$57 \$1 via_stack$8
X$139 \$57 \$1 via_stack$8
X$140 \$57 \$1 via_stack$7
X$141 \$57 \$1 via_stack$7
X$142 \$57 \$1 via_stack$7
X$143 \$57 \$1 via_stack$7
X$144 \$57 \$1 via_stack$7
X$145 \$58 \$1 via_stack$7
X$146 \$58 \$1 via_stack$7
X$147 \$58 \$1 via_stack$7
X$148 \$58 \$1 via_stack$7
X$149 \$58 \$1 via_stack$7
X$150 \$58 \$1 via_stack$7
X$151 \$58 \$1 via_stack$9
X$152 \$58 \$1 via_stack$9
X$153 \$57 \$1 via_stack$9
X$154 \$57 \$1 via_stack$19
X$155 GND \$1 via_stack$1
X$156 GND \$1 via_stack$1
X$157 VDD \$1 via_stack$1
X$158 VDD \$1 via_stack$1
X$159 \$81 \$1 via_stack$1
X$160 VDD \$1 via_stack$1
X$161 \$243 \$1 via_stack$1
X$162 \$243 \$1 via_stack$1
X$163 \$243 \$1 via_stack$1
X$164 VDD \$1 via_stack$1
X$165 Iref \$1 via_stack$1
X$166 \$81 \$1 via_stack$1
X$167 \$81 \$1 via_stack$1
X$168 Iref \$1 via_stack$1
X$169 \$81 \$1 via_stack$1
X$170 \$81 \$1 via_stack$1
X$171 \$243 \$1 via_stack$1
X$172 \$243 \$1 via_stack$1
X$173 \$81 \$1 via_stack$1
X$174 \$243 \$1 via_stack$1
X$175 \$81 \$1 via_stack$1
X$176 \$81 \$1 via_stack$1
X$177 \$81 \$1 via_stack$1
X$178 \$88 \$1 via_stack$1
X$179 \$88 \$1 via_stack$1
X$180 \$88 \$1 via_stack$1
X$181 \$81 \$1 via_stack$1
X$182 \$81 \$1 via_stack$1
X$183 GND \$1 via_stack$1
X$184 GND \$1 via_stack$17
X$185 \$69 \$1 via_stack$17
X$186 \$85 \$1 via_stack
X$187 \$81 \$1 via_stack
X$188 \$147 \$1 via_stack
X$189 \$81 \$1 via_stack
X$190 \$147 \$1 via_stack
X$191 GND \$1 via_stack
X$192 \$147 \$1 via_stack
X$193 GND \$1 via_stack
X$194 \$147 \$1 via_stack
X$195 \$147 \$1 via_stack
X$196 \$81 \$1 via_stack
X$197 \$147 \$1 via_stack
X$198 \$147 \$1 via_stack
X$199 VDD \$1 via_stack
X$200 \$143 \$1 via_stack
X$201 \$143 \$1 via_stack
X$202 GND \$1 via_stack
X$203 \$70 \$1 via_stack
X$204 \$123 \$1 via_stack
X$205 GND \$1 via_stack
X$206 \$70 \$1 via_stack
X$207 \$143 \$1 via_stack
X$208 \$81 \$1 via_stack
X$209 \$143 \$1 via_stack
X$210 \$81 \$1 via_stack
X$211 \$81 \$1 via_stack
X$212 \$143 \$1 via_stack
X$213 \$143 \$1 via_stack
X$214 VDD \$1 via_stack
X$215 VDD \$1 via_stack
X$216 VDD \$1 via_stack
X$217 VDD \$1 via_stack
X$218 VDD \$1 via_stack
X$219 VDD \$1 via_stack
X$220 \$85 \$1 via_stack
X$221 \$94 \$1 via_stack
X$222 VDD \$1 via_stack
X$223 \$88 \$1 via_stack
X$224 \$143 \$1 via_stack
X$225 VDD \$1 via_stack
X$226 VDD \$1 via_stack
X$227 VDD \$1 via_stack
X$228 \$1 GND ptap1
X$229 \$14 \$9 \$1 rppd
X$230 \$24 \$18 \$1 rppd
X$231 \$40 \$34 \$1 rppd
X$232 \$55 \$53 \$1 rppd
X$233 \$46 \$53 \$1 rppd
X$234 \$16 \$9 \$1 rppd
X$235 \$30 \$25 \$1 rppd
X$236 \$32 \$25 \$1 rppd
X$237 \$55 \$85 \$1 rppd
X$238 \$24 \$17 \$1 rppd
X$239 \$32 \$26 \$1 rppd
X$240 \$22 \$26 \$1 rppd
X$241 \$22 \$17 \$1 rppd
X$242 \$30 \$34 \$1 rppd
X$243 \$48 \$42 \$1 rppd
X$244 \$38 \$42 \$1 rppd
X$245 \$38 \$33 \$1 rppd
X$246 \$40 \$33 \$1 rppd
X$247 \$48 \$41 \$1 rppd
X$248 \$16 \$10 \$1 rppd
X$249 \$46 \$41 \$1 rppd
X$250 \$14 \$18 \$1 rppd
X$251 \$7 \$10 \$1 rppd
X$252 \$7 \$3 \$1 rppd
X$253 \$13 \$11 \$1 rppd$1
X$254 \$21 \$23 \$1 rppd$1
X$255 \$20 \$23 \$1 rppd$1
X$256 \$20 \$11 \$1 rppd$1
X$257 \$21 \$19 \$1 rppd$1
X$258 \$54 \$56 \$1 rppd$1
X$259 \$28 \$31 \$1 rppd$1
X$260 \$29 \$31 \$1 rppd$1
X$261 \$29 \$27 \$1 rppd$1
X$262 \$54 \$43 \$1 rppd$1
X$263 \$36 \$27 \$1 rppd$1
X$264 \$36 \$39 \$1 rppd$1
X$265 \$37 \$39 \$1 rppd$1
X$266 \$28 \$19 \$1 rppd$1
X$267 \$44 \$35 \$1 rppd$1
X$268 \$44 \$47 \$1 rppd$1
X$269 \$70 \$56 \$1 rppd$1
X$270 \$13 \$15 \$1 rppd$1
X$271 \$12 \$15 \$1 rppd$1
X$272 \$12 \$8 \$1 rppd$1
X$273 \$4 \$8 \$1 rppd$1
X$274 \$45 \$43 \$1 rppd$1
X$275 \$37 \$35 \$1 rppd$1
X$276 \$45 \$47 \$1 rppd$1
X$277 GND \$1 via_stack$20
X$278 \$1 GND ptap1$1
X$279 GND \$1 via_stack$12
X$280 VDD \$1 via_stack$12
X$281 VDD \$1 via_stack$12
X$282 VDD \$1 via_stack$12
X$283 VDD \$1 via_stack$12
X$284 \$69 GND \$1 \$94 nmos$2
X$285 \$69 \$57 \$1 \$123 nmos$2
X$286 \$85 \$1 via_stack$15
X$287 \$70 \$1 via_stack$15
X$288 \$88 \$58 \$68 \$1 \$58 pmos$2
X$289 \$58 \$88 \$68 \$1 \$58 pmos$2
X$290 \$88 \$58 \$68 \$1 \$58 pmos$2
X$291 \$58 \$88 \$68 \$1 \$58 pmos$2
X$292 \$88 \$58 \$68 \$1 \$58 pmos$2
X$293 \$58 \$88 \$68 \$1 \$58 pmos$2
X$294 \$88 \$58 \$68 \$1 \$58 pmos$2
X$295 \$58 \$88 \$68 \$1 \$58 pmos$2
X$296 \$88 \$58 \$68 \$1 \$58 pmos$2
X$297 \$58 \$88 \$68 \$1 \$58 pmos$2
X$298 \$88 \$93 \$68 \$1 \$58 pmos$2
X$299 \$88 \$58 \$68 \$1 \$58 pmos$2
X$300 \$58 \$88 \$68 \$1 \$58 pmos$2
X$301 \$88 \$58 \$68 \$1 \$58 pmos$2
X$302 \$58 \$88 \$68 \$1 \$58 pmos$2
X$303 \$88 \$58 \$68 \$1 \$58 pmos$2
X$304 \$58 \$88 \$68 \$1 \$58 pmos$2
X$305 \$88 \$58 \$68 \$1 \$58 pmos$2
X$306 \$58 \$88 \$68 \$1 \$58 pmos$2
X$307 \$88 \$58 \$68 \$1 \$58 pmos$2
X$308 \$58 \$88 \$68 \$1 \$58 pmos$2
X$309 \$69 \$94 \$1 \$94 nmos$1
X$310 \$94 \$69 \$1 \$94 nmos$1
X$311 \$69 \$94 \$1 \$94 nmos$1
X$312 \$94 \$69 \$1 \$94 nmos$1
X$313 \$69 \$94 \$1 \$94 nmos$1
X$314 \$94 \$69 \$1 \$94 nmos$1
X$315 \$69 \$94 \$1 \$94 nmos$1
X$316 \$94 \$69 \$1 \$94 nmos$1
X$317 \$69 \$94 \$1 \$94 nmos$1
X$318 \$94 \$69 \$1 \$94 nmos$1
X$319 \$69 \$94 \$1 \$94 nmos$1
X$320 \$94 \$69 \$1 \$94 nmos$1
X$321 \$69 \$94 \$1 \$94 nmos$1
X$322 \$94 \$69 \$1 \$94 nmos$1
X$323 \$69 \$94 \$1 \$94 nmos$1
X$324 \$69 \$94 \$1 \$94 nmos$1
X$325 \$94 \$69 \$1 \$94 nmos$1
X$326 \$69 \$94 \$1 \$94 nmos$1
X$327 \$94 \$69 \$1 \$94 nmos$1
X$328 \$69 \$94 \$1 \$94 nmos$1
X$329 \$94 \$69 \$1 \$94 nmos$1
X$330 \$69 \$94 \$1 \$94 nmos$1
X$331 \$94 \$69 \$1 \$94 nmos$1
X$332 \$69 \$94 \$1 \$94 nmos$1
X$333 \$94 \$69 \$1 \$94 nmos$1
X$334 \$69 \$94 \$1 \$94 nmos$1
X$335 \$94 \$69 \$1 \$94 nmos$1
X$336 \$69 \$94 \$1 \$94 nmos$1
X$337 \$94 \$69 \$1 \$94 nmos$1
X$338 \$69 \$94 \$1 \$94 nmos$1
X$339 \$69 \$1 via_stack$15
X$340 \$123 \$57 \$1 \$123 nmos$1
X$341 \$57 \$123 \$1 \$123 nmos$1
X$342 \$57 \$123 \$1 \$123 nmos$1
X$343 \$123 \$57 \$1 \$123 nmos$1
X$344 \$57 \$123 \$1 \$123 nmos$1
X$345 \$123 \$57 \$1 \$123 nmos$1
X$346 \$57 \$123 \$1 \$123 nmos$1
X$347 \$123 \$57 \$1 \$123 nmos$1
X$348 \$57 \$123 \$1 \$123 nmos$1
X$349 \$123 \$57 \$1 \$123 nmos$1
X$350 \$57 \$123 \$1 \$123 nmos$1
X$351 \$123 \$57 \$1 \$123 nmos$1
X$352 \$57 \$123 \$1 \$123 nmos$1
X$353 \$123 \$57 \$1 \$123 nmos$1
X$354 \$57 \$123 \$1 \$123 nmos$1
X$355 \$57 \$123 \$1 \$123 nmos$1
X$356 \$123 \$57 \$1 \$123 nmos$1
X$357 \$57 \$123 \$1 \$123 nmos$1
X$358 \$123 \$57 \$1 \$123 nmos$1
X$359 \$57 \$123 \$1 \$123 nmos$1
X$360 \$123 \$57 \$1 \$123 nmos$1
X$361 \$57 \$123 \$1 \$123 nmos$1
X$362 \$123 \$57 \$1 \$123 nmos$1
X$363 \$57 \$123 \$1 \$123 nmos$1
X$364 \$123 \$57 \$1 \$123 nmos$1
X$365 \$57 \$123 \$1 \$123 nmos$1
X$366 \$123 \$57 \$1 \$123 nmos$1
X$367 \$57 \$123 \$1 \$123 nmos$1
X$368 \$123 \$57 \$1 \$123 nmos$1
X$369 \$57 \$123 \$1 \$123 nmos$1
M$1 GND \$94 \$69 \$1 sg13_lv_nmos L=1.2u W=0.5u AS=0.17p AD=0.095p PS=1.68u
+ PD=0.88u
M$2 \$69 \$123 \$57 \$1 sg13_lv_nmos L=1.2u W=0.5u AS=0.095p AD=0.17p PS=0.88u
+ PD=1.68u
M$3 \$57 \$123 \$123 \$1 sg13_lv_nmos L=0.26u W=10u AS=3.4p AD=1.9p PS=20.68u
+ PD=10.38u
M$4 \$123 \$123 \$57 \$1 sg13_lv_nmos L=0.26u W=10u AS=1.9p AD=1.9p PS=10.38u
+ PD=10.38u
M$5 \$57 \$123 \$123 \$1 sg13_lv_nmos L=0.26u W=10u AS=1.9p AD=1.9p PS=10.38u
+ PD=10.38u
M$6 \$123 \$123 \$57 \$1 sg13_lv_nmos L=0.26u W=10u AS=1.9p AD=1.9p PS=10.38u
+ PD=10.38u
M$7 \$57 \$123 \$123 \$1 sg13_lv_nmos L=0.26u W=10u AS=1.9p AD=1.9p PS=10.38u
+ PD=10.38u
M$8 \$123 \$123 \$57 \$1 sg13_lv_nmos L=0.26u W=10u AS=1.9p AD=1.9p PS=10.38u
+ PD=10.38u
M$9 \$57 \$123 \$123 \$1 sg13_lv_nmos L=0.26u W=10u AS=1.9p AD=1.9p PS=10.38u
+ PD=10.38u
M$10 \$123 \$123 \$57 \$1 sg13_lv_nmos L=0.26u W=10u AS=1.9p AD=1.9p PS=10.38u
+ PD=10.38u
M$11 \$57 \$123 \$123 \$1 sg13_lv_nmos L=0.26u W=10u AS=1.9p AD=1.9p PS=10.38u
+ PD=10.38u
M$12 \$123 \$123 \$57 \$1 sg13_lv_nmos L=0.26u W=10u AS=1.9p AD=1.9p PS=10.38u
+ PD=10.38u
M$13 \$57 \$123 \$123 \$1 sg13_lv_nmos L=0.26u W=10u AS=1.9p AD=1.9p PS=10.38u
+ PD=10.38u
M$14 \$123 \$123 \$57 \$1 sg13_lv_nmos L=0.26u W=10u AS=1.9p AD=1.9p PS=10.38u
+ PD=10.38u
M$15 \$57 \$123 \$123 \$1 sg13_lv_nmos L=0.26u W=10u AS=1.9p AD=1.9p PS=10.38u
+ PD=10.38u
M$16 \$123 \$123 \$57 \$1 sg13_lv_nmos L=0.26u W=10u AS=1.9p AD=1.9p PS=10.38u
+ PD=10.38u
M$17 \$57 \$123 \$123 \$1 sg13_lv_nmos L=0.26u W=10u AS=1.9p AD=3.4p PS=10.38u
+ PD=20.68u
M$18 \$94 \$94 \$69 \$1 sg13_lv_nmos L=0.26u W=10u AS=3.4p AD=1.9p PS=20.68u
+ PD=10.38u
M$19 \$69 \$94 \$94 \$1 sg13_lv_nmos L=0.26u W=10u AS=1.9p AD=1.9p PS=10.38u
+ PD=10.38u
M$20 \$94 \$94 \$69 \$1 sg13_lv_nmos L=0.26u W=10u AS=1.9p AD=1.9p PS=10.38u
+ PD=10.38u
M$21 \$69 \$94 \$94 \$1 sg13_lv_nmos L=0.26u W=10u AS=1.9p AD=1.9p PS=10.38u
+ PD=10.38u
M$22 \$94 \$94 \$69 \$1 sg13_lv_nmos L=0.26u W=10u AS=1.9p AD=1.9p PS=10.38u
+ PD=10.38u
M$23 \$69 \$94 \$94 \$1 sg13_lv_nmos L=0.26u W=10u AS=1.9p AD=1.9p PS=10.38u
+ PD=10.38u
M$24 \$94 \$94 \$69 \$1 sg13_lv_nmos L=0.26u W=10u AS=1.9p AD=1.9p PS=10.38u
+ PD=10.38u
M$25 \$69 \$94 \$94 \$1 sg13_lv_nmos L=0.26u W=10u AS=1.9p AD=1.9p PS=10.38u
+ PD=10.38u
M$26 \$94 \$94 \$69 \$1 sg13_lv_nmos L=0.26u W=10u AS=1.9p AD=1.9p PS=10.38u
+ PD=10.38u
M$27 \$69 \$94 \$94 \$1 sg13_lv_nmos L=0.26u W=10u AS=1.9p AD=1.9p PS=10.38u
+ PD=10.38u
M$28 \$94 \$94 \$69 \$1 sg13_lv_nmos L=0.26u W=10u AS=1.9p AD=1.9p PS=10.38u
+ PD=10.38u
M$29 \$69 \$94 \$94 \$1 sg13_lv_nmos L=0.26u W=10u AS=1.9p AD=1.9p PS=10.38u
+ PD=10.38u
M$30 \$94 \$94 \$69 \$1 sg13_lv_nmos L=0.26u W=10u AS=1.9p AD=1.9p PS=10.38u
+ PD=10.38u
M$31 \$69 \$94 \$94 \$1 sg13_lv_nmos L=0.26u W=10u AS=1.9p AD=1.9p PS=10.38u
+ PD=10.38u
M$32 \$94 \$94 \$69 \$1 sg13_lv_nmos L=0.26u W=10u AS=1.9p AD=3.4p PS=10.38u
+ PD=20.68u
M$33 \$94 \$94 \$69 \$1 sg13_lv_nmos L=0.26u W=10u AS=3.4p AD=1.9p PS=20.68u
+ PD=10.38u
M$34 \$69 \$94 \$94 \$1 sg13_lv_nmos L=0.26u W=10u AS=1.9p AD=1.9p PS=10.38u
+ PD=10.38u
M$35 \$94 \$94 \$69 \$1 sg13_lv_nmos L=0.26u W=10u AS=1.9p AD=1.9p PS=10.38u
+ PD=10.38u
M$36 \$69 \$94 \$94 \$1 sg13_lv_nmos L=0.26u W=10u AS=1.9p AD=1.9p PS=10.38u
+ PD=10.38u
M$37 \$94 \$94 \$69 \$1 sg13_lv_nmos L=0.26u W=10u AS=1.9p AD=1.9p PS=10.38u
+ PD=10.38u
M$38 \$69 \$94 \$94 \$1 sg13_lv_nmos L=0.26u W=10u AS=1.9p AD=1.9p PS=10.38u
+ PD=10.38u
M$39 \$94 \$94 \$69 \$1 sg13_lv_nmos L=0.26u W=10u AS=1.9p AD=1.9p PS=10.38u
+ PD=10.38u
M$40 \$69 \$94 \$94 \$1 sg13_lv_nmos L=0.26u W=10u AS=1.9p AD=1.9p PS=10.38u
+ PD=10.38u
M$41 \$94 \$94 \$69 \$1 sg13_lv_nmos L=0.26u W=10u AS=1.9p AD=1.9p PS=10.38u
+ PD=10.38u
M$42 \$69 \$94 \$94 \$1 sg13_lv_nmos L=0.26u W=10u AS=1.9p AD=1.9p PS=10.38u
+ PD=10.38u
M$43 \$94 \$94 \$69 \$1 sg13_lv_nmos L=0.26u W=10u AS=1.9p AD=1.9p PS=10.38u
+ PD=10.38u
M$44 \$69 \$94 \$94 \$1 sg13_lv_nmos L=0.26u W=10u AS=1.9p AD=1.9p PS=10.38u
+ PD=10.38u
M$45 \$94 \$94 \$69 \$1 sg13_lv_nmos L=0.26u W=10u AS=1.9p AD=1.9p PS=10.38u
+ PD=10.38u
M$46 \$69 \$94 \$94 \$1 sg13_lv_nmos L=0.26u W=10u AS=1.9p AD=1.9p PS=10.38u
+ PD=10.38u
M$47 \$94 \$94 \$69 \$1 sg13_lv_nmos L=0.26u W=10u AS=1.9p AD=3.4p PS=10.38u
+ PD=20.68u
M$48 \$57 \$123 \$123 \$1 sg13_lv_nmos L=0.26u W=10u AS=3.4p AD=1.9p PS=20.68u
+ PD=10.38u
M$49 \$123 \$123 \$57 \$1 sg13_lv_nmos L=0.26u W=10u AS=1.9p AD=1.9p PS=10.38u
+ PD=10.38u
M$50 \$57 \$123 \$123 \$1 sg13_lv_nmos L=0.26u W=10u AS=1.9p AD=1.9p PS=10.38u
+ PD=10.38u
M$51 \$123 \$123 \$57 \$1 sg13_lv_nmos L=0.26u W=10u AS=1.9p AD=1.9p PS=10.38u
+ PD=10.38u
M$52 \$57 \$123 \$123 \$1 sg13_lv_nmos L=0.26u W=10u AS=1.9p AD=1.9p PS=10.38u
+ PD=10.38u
M$53 \$123 \$123 \$57 \$1 sg13_lv_nmos L=0.26u W=10u AS=1.9p AD=1.9p PS=10.38u
+ PD=10.38u
M$54 \$57 \$123 \$123 \$1 sg13_lv_nmos L=0.26u W=10u AS=1.9p AD=1.9p PS=10.38u
+ PD=10.38u
M$55 \$123 \$123 \$57 \$1 sg13_lv_nmos L=0.26u W=10u AS=1.9p AD=1.9p PS=10.38u
+ PD=10.38u
M$56 \$57 \$123 \$123 \$1 sg13_lv_nmos L=0.26u W=10u AS=1.9p AD=1.9p PS=10.38u
+ PD=10.38u
M$57 \$123 \$123 \$57 \$1 sg13_lv_nmos L=0.26u W=10u AS=1.9p AD=1.9p PS=10.38u
+ PD=10.38u
M$58 \$57 \$123 \$123 \$1 sg13_lv_nmos L=0.26u W=10u AS=1.9p AD=1.9p PS=10.38u
+ PD=10.38u
M$59 \$123 \$123 \$57 \$1 sg13_lv_nmos L=0.26u W=10u AS=1.9p AD=1.9p PS=10.38u
+ PD=10.38u
M$60 \$57 \$123 \$123 \$1 sg13_lv_nmos L=0.26u W=10u AS=1.9p AD=1.9p PS=10.38u
+ PD=10.38u
M$61 \$123 \$123 \$57 \$1 sg13_lv_nmos L=0.26u W=10u AS=1.9p AD=1.9p PS=10.38u
+ PD=10.38u
M$62 \$57 \$123 \$123 \$1 sg13_lv_nmos L=0.26u W=10u AS=1.9p AD=3.4p PS=10.38u
+ PD=20.68u
M$63 \$88 \$58 \$58 \$68 sg13_lv_pmos L=0.36u W=10u AS=3.4p AD=1.9p PS=20.68u
+ PD=10.38u
M$64 \$58 \$58 \$88 \$68 sg13_lv_pmos L=0.36u W=10u AS=1.9p AD=1.9p PS=10.38u
+ PD=10.38u
M$65 \$88 \$58 \$58 \$68 sg13_lv_pmos L=0.36u W=10u AS=1.9p AD=1.9p PS=10.38u
+ PD=10.38u
M$66 \$58 \$58 \$88 \$68 sg13_lv_pmos L=0.36u W=10u AS=1.9p AD=1.9p PS=10.38u
+ PD=10.38u
M$67 \$88 \$58 \$58 \$68 sg13_lv_pmos L=0.36u W=10u AS=1.9p AD=1.9p PS=10.38u
+ PD=10.38u
M$68 \$58 \$58 \$88 \$68 sg13_lv_pmos L=0.36u W=10u AS=1.9p AD=1.9p PS=10.38u
+ PD=10.38u
M$69 \$88 \$58 \$58 \$68 sg13_lv_pmos L=0.36u W=10u AS=1.9p AD=1.9p PS=10.38u
+ PD=10.38u
M$70 \$58 \$58 \$88 \$68 sg13_lv_pmos L=0.36u W=10u AS=1.9p AD=1.9p PS=10.38u
+ PD=10.38u
M$71 \$88 \$58 \$58 \$68 sg13_lv_pmos L=0.36u W=10u AS=1.9p AD=1.9p PS=10.38u
+ PD=10.38u
M$72 \$58 \$58 \$88 \$68 sg13_lv_pmos L=0.36u W=10u AS=1.9p AD=1.9p PS=10.38u
+ PD=10.38u
M$73 \$88 \$58 \$93 \$68 sg13_lv_pmos L=0.36u W=10u AS=1.9p AD=3.4p PS=10.38u
+ PD=20.68u
M$74 \$88 \$58 \$58 \$68 sg13_lv_pmos L=0.36u W=10u AS=3.4p AD=1.9p PS=20.68u
+ PD=10.38u
M$75 \$58 \$58 \$88 \$68 sg13_lv_pmos L=0.36u W=10u AS=1.9p AD=1.9p PS=10.38u
+ PD=10.38u
M$76 \$88 \$58 \$58 \$68 sg13_lv_pmos L=0.36u W=10u AS=1.9p AD=1.9p PS=10.38u
+ PD=10.38u
M$77 \$58 \$58 \$88 \$68 sg13_lv_pmos L=0.36u W=10u AS=1.9p AD=1.9p PS=10.38u
+ PD=10.38u
M$78 \$88 \$58 \$58 \$68 sg13_lv_pmos L=0.36u W=10u AS=1.9p AD=1.9p PS=10.38u
+ PD=10.38u
M$79 \$58 \$58 \$88 \$68 sg13_lv_pmos L=0.36u W=10u AS=1.9p AD=1.9p PS=10.38u
+ PD=10.38u
M$80 \$88 \$58 \$58 \$68 sg13_lv_pmos L=0.36u W=10u AS=1.9p AD=1.9p PS=10.38u
+ PD=10.38u
M$81 \$58 \$58 \$88 \$68 sg13_lv_pmos L=0.36u W=10u AS=1.9p AD=1.9p PS=10.38u
+ PD=10.38u
M$82 \$88 \$58 \$58 \$68 sg13_lv_pmos L=0.36u W=10u AS=1.9p AD=1.9p PS=10.38u
+ PD=10.38u
M$83 \$58 \$58 \$88 \$68 sg13_lv_pmos L=0.36u W=10u AS=1.9p AD=3.4p PS=10.38u
+ PD=20.68u
R$84 \$68 VDD ntap1 A=8p P=18u
R$85 \$79 VDD ntap1 A=20p P=42u
R$86 \$237 VDD ntap1 A=5p P=12u
R$87 \$237 VDD ntap1 A=5p P=12u
R$88 \$73 VDD ntap1 A=20p P=42u
.ENDS ctat_ptat_up_mirror

.SUBCKT rhigh \$1 \$2 \$3
R$1 \$1 \$2 rhigh w=0.5u l=27u ps=0 b=0 m=1
.ENDS rhigh

.SUBCKT via_stack$20 \$1 \$2
.ENDS via_stack$20

.SUBCKT via_stack$19 \$1 \$2
.ENDS via_stack$19

.SUBCKT nmos$2 \$1 \$2 \$3 \$5
.ENDS nmos$2

.SUBCKT via_stack$18 \$1 \$2
.ENDS via_stack$18

.SUBCKT ptap1$1 \$1 \$2
R$1 \$1 \$2 ptap1 A=19p P=40u
.ENDS ptap1$1

.SUBCKT nmos$1 \$1 \$2 \$3 \$5
.ENDS nmos$1

.SUBCKT via_stack$17 \$1 \$2
.ENDS via_stack$17

.SUBCKT via_stack$16 \$1 \$2
.ENDS via_stack$16

.SUBCKT via_stack$15 \$1 \$2
.ENDS via_stack$15

.SUBCKT via_stack$14 \$1 \$2
.ENDS via_stack$14

.SUBCKT ntap1 \$1 \$2 \$4
.ENDS ntap1

.SUBCKT via_stack$4 \$1 \$2
.ENDS via_stack$4

.SUBCKT via_stack$12 \$1 \$2
.ENDS via_stack$12

.SUBCKT via_stack$5 \$1 \$2
.ENDS via_stack$5

.SUBCKT via_stack$6 \$1 \$2
.ENDS via_stack$6

.SUBCKT via_stack$9 \$1 \$2
.ENDS via_stack$9

.SUBCKT via_stack$8 \$1 \$2
.ENDS via_stack$8

.SUBCKT ptap1 \$1 \$2
R$1 \$1 \$2 ptap1 A=56p P=114u
.ENDS ptap1

.SUBCKT pmos$2 \$1 \$2 \$3 \$5 \$6
.ENDS pmos$2

.SUBCKT rppd \$1 \$2 \$3
R$1 \$1 \$2 rppd w=0.5u l=46.8u ps=0 b=0 m=1
.ENDS rppd

.SUBCKT ntap1$1 \$1 \$2 \$4
.ENDS ntap1$1

.SUBCKT via_stack$11 \$1 \$2
.ENDS via_stack$11

.SUBCKT pmos$1 \$1 \$2 \$3 \$5 \$6
M$1 \$1 \$6 \$2 \$3 sg13_lv_pmos L=0.5u W=10u AS=3.4p AD=3.4p PS=20.68u
+ PD=20.68u
.ENDS pmos$1

.SUBCKT ntap1$2 \$1 \$2 \$4
.ENDS ntap1$2

.SUBCKT nmos \$1 \$2 \$3 \$5
M$1 \$1 \$5 \$2 \$3 sg13_lv_nmos L=8u W=10u AS=3.4p AD=3.4p PS=20.68u PD=20.68u
.ENDS nmos

.SUBCKT via_stack$7 \$1 \$2
.ENDS via_stack$7

.SUBCKT rppd$1 \$1 \$2 \$3
R$1 \$1 \$2 rppd w=0.5u l=84.4u ps=0 b=0 m=1
.ENDS rppd$1

.SUBCKT via_stack$10 \$1 \$2
.ENDS via_stack$10

.SUBCKT via_stack \$1 \$2
.ENDS via_stack

.SUBCKT via_stack$1 \$1 \$2
.ENDS via_stack$1

.SUBCKT pmos \$1 \$2 \$3 \$5 \$6
M$1 \$1 \$6 \$2 \$3 sg13_lv_pmos L=2u W=1u AS=0.34p AD=0.34p PS=2.68u PD=2.68u
.ENDS pmos
