* Extracted by KLayout with SG13G2 LVS runset on : 28/03/2026 23:29

.SUBCKT out_mirror GND Ibias_2 Ibias_3 Ibias_4 Ibias_5 Ibias_6 Ibias_1 IREF
+ Vb_0v4 VDD Vb_0v5
R$1 \$3 VDD ntap1 A=37.8p P=120.6u
R$15 GND Vb_0v4 rppd w=0.5u l=792u ps=0 b=0 m=1
C$22 \$4 VDD cap_cmim w=2.6u l=2.6u A=6.76p P=10.4u m=1
M$23 IREF IREF GND \$1 sg13_lv_nmos L=2u W=3.3u AS=1.122p AD=1.122p PS=8.64u
+ PD=8.64u
M$24 GND IREF \$4 \$1 sg13_lv_nmos L=2u W=3.3u AS=1.122p AD=1.122p PS=8.64u
+ PD=8.64u
R$29 \$1 GND ptap1 A=5p P=12u
R$42 Vb_0v4 \$31 rppd w=0.5u l=1167.4u ps=0 b=0 m=1
R$50 Vb_0v5 GND rppd w=0.5u l=994u ps=0 b=0 m=1
R$73 Vb_0v5 \$29 rppd w=0.5u l=972.9u ps=0 b=0 m=1
M$81 \$4 \$4 VDD \$3 sg13_lv_pmos L=2u W=6.6u AS=2.244p AD=2.244p PS=17.28u
+ PD=17.28u
M$82 Ibias_4 \$4 VDD \$3 sg13_lv_pmos L=2u W=6.6u AS=2.244p AD=2.244p PS=17.28u
+ PD=17.28u
M$85 Ibias_5 \$4 VDD \$3 sg13_lv_pmos L=2u W=6.6u AS=2.244p AD=2.244p PS=17.28u
+ PD=17.28u
M$89 VDD \$4 Ibias_6 \$3 sg13_lv_pmos L=2u W=6.6u AS=2.244p AD=2.244p PS=17.28u
+ PD=17.28u
M$91 VDD \$4 \$29 \$3 sg13_lv_pmos L=2u W=6.6u AS=2.244p AD=2.244p PS=17.28u
+ PD=17.28u
M$93 Ibias_1 \$4 VDD \$3 sg13_lv_pmos L=2u W=6.6u AS=2.244p AD=2.244p PS=17.28u
+ PD=17.28u
M$96 VDD \$4 \$31 \$3 sg13_lv_pmos L=2u W=6.6u AS=2.244p AD=2.244p PS=17.28u
+ PD=17.28u
M$122 VDD \$4 Ibias_3 \$3 sg13_lv_pmos L=2u W=6.6u AS=2.244p AD=2.244p
+ PS=17.28u PD=17.28u
M$123 VDD \$4 Ibias_2 \$3 sg13_lv_pmos L=2u W=6.6u AS=2.244p AD=2.244p
+ PS=17.28u PD=17.28u
C$135 IREF GND cap_cmim w=18u l=18u A=324p P=72u m=9
.ENDS out_mirror
