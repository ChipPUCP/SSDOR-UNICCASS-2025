* Extracted by KLayout with SG13G2 LVS runset on : 11/03/2026 03:03

.SUBCKT logic_shift_down_v1 VSS VDDL OUT IN
M$1 VSS IN \$3 VSS sg13_lv_nmos L=0.13u W=1u AS=0.34p AD=0.34p PS=2.68u PD=2.68u
M$2 VSS \$3 OUT VSS sg13_lv_nmos L=0.13u W=1u AS=0.34p AD=0.34p PS=2.68u
+ PD=2.68u
M$3 VDDL IN \$3 VDDL sg13_lv_pmos L=0.13u W=2u AS=0.68p AD=0.68p PS=4.68u
+ PD=4.68u
M$4 VDDL \$3 OUT VDDL sg13_lv_pmos L=0.13u W=2u AS=0.68p AD=0.68p PS=4.68u
+ PD=4.68u
.ENDS logic_shift_down_v1
