** sch_path: /home/designer/shared/designs/SSDOR_1.2V_v2-1/components/logic_shift_down_v1/logic_shift_down_v1.sch
.subckt logic_shift_down_v1 VDDL IN OUT VSS
*.PININFO IN:I OUT:O VDDL:B VSS:B
M1 net1 IN VDDL VDDL sg13_lv_pmos w=2u l=0.13u ng=1 m=1
M2 net1 IN VSS VSS sg13_lv_nmos w=1u l=0.13u ng=1 m=1
M3 OUT net1 VDDL VDDL sg13_lv_pmos w=2u l=0.13u ng=1 m=1
M4 OUT net1 VSS VSS sg13_lv_nmos w=1u l=0.13u ng=1 m=1
.ends
