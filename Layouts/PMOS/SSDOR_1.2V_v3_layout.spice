** sch_path: /shared/designs/SSDOR_1.2V_v3/SSDOR_1.2V_v3_layout.sch
.subckt SSDOR_1.2V_v3_layout

M3 Vp Vn GND GND sg13_lv_nmos w=10.385u l=0.13u ng=2 m=2
M5 Vb1 Vp Vout_1 Vb1 sg13_lv_pmos w=9u l=0.13u ng=1 m=1
M6 Vb1 Vout_1 Vp Vb1 sg13_lv_pmos w=3u l=0.13u ng=1 m=1
M7 Vb3 Vn Vout_1 Vb3 sg13_lv_pmos w=9u l=0.13u ng=1 m=1
M8 Vb3 Vout_1 Vn Vb3 sg13_lv_pmos w=3u l=0.13u ng=1 m=1
Vin Vp Vn dc 0 sin 0 {Vin} 10meg 0
C1 Vout_1 GND {C1} m=1
R1 net2 GND {R1} m=1
Vamp_1 Vout_1 net2 0
M11 Vb2 Vp Vout_2 Vb2 sg13_lv_pmos w=9u l=0.13u ng=1 m=1
M12 Vb2 Vout_2 Vp Vb2 sg13_lv_pmos w=3u l=0.13u ng=1 m=1
M13 Vb4 Vn Vout_2 Vb4 sg13_lv_pmos w=9u l=0.13u ng=1 m=1
M14 Vb4 Vout_2 Vn Vb4 sg13_lv_pmos w=3u l=0.13u ng=1 m=1
C2 Vout_2 GND {C2} m=1
R2 net4 GND {R2} m=1
Vamp_2 Vout_2 net4 0
M21 Vx1 Vx1 Vout_1 Vout_1 sg13_lv_pmos w=0.5u l=10u ng=1 m=19
M22 Vx1 Vx1 GND GND sg13_lv_nmos w=0.5u l=10u ng=1 m=1
M23 Vx2 Vx2 Vout_2 Vout_2 sg13_lv_pmos w=0.5u l=10u ng=1 m=10
M24 Vx2 Vx2 GND GND sg13_lv_nmos w=0.5u l=10u ng=1 m=1
Vamp_d2 Vout_2 net3 0
Vamp_d1 Vout_1 net1 0
Vamp_buff2 net3 net9 0
Vamp_buff1 net1 net10 0
Vmeas Ibias_4 net7 0
.save i(vmeas)
Vmeas1 Ibias_2 net6 0
.save i(vmeas1)
Vmeas2 Ibias_1 net5 0
.save i(vmeas2)
Vmeas3 Ibias_3 net8 0
.save i(vmeas3)
Vamp_id Vout_2 net19 0
x2 net19 GND Ibias_4 Ibias_1 Ibias_2 Ibias_5 Ibias_6 Ibias_3 Vb0v5 Vb0v4 CTAT_PTAT
x16 Vout_2 GND Vb0v4 Vx1 X Ibias_5 comp_w_hyst
x18 Vout_2 GND Vb0v5 Vx2 Y Ibias_6 comp_w_hyst
x19 Vout_2 X S1_p CLKg Y S2 GND logic_controller
x15 Vout_1 S1_p S1 GND logic_shift_down_v1
x3 Vp net3 Vcomp2 net8 GND pmos_comp
x4 Vp net1 Vcomp1 net5 GND pmos_comp
x6 Vn Vout_1 net13 net6 GND pmos_comp
x10 Vn Vout_2 net15 net7 GND pmos_comp
x1 net3 Vout_2 S2 net11 Vcomp2 GND mux
x7 net1 Vout_1 S1 net12 Vcomp1 GND mux
x8 Vout_2 Vout_2 S2 net16 net15 GND mux
x14 Vout_1 Vout_1 S1 net14 net13 GND mux
x5 net9 net11 net20 GND buffer wn=1u
x11 net10 net12 net23 GND buffer wn=1u
x12 Vout_2 net16 net17 GND buffer wn=1u
x13 Vout_1 net14 net18 GND buffer wn=1u
xcg1 Vout_2 CLKg GND cgenerator
Vsw_11_s Vout_2 net24 0
Vsw_11_g net22 net20 0
Vsw_11_d net21 Vp 0
x9 net24 net22 Vb2 net21 pmos_array
x17 Vout_2 net17 Vb4 Vn pmos_array
x20 Vout_1 net18 Vb3 Vn pmos_array
x21 Vout_1 net23 Vb1 Vp pmos_array
M1 Vn Vp GND GND sg13_lv_nmos w=10.385u l=0.13u ng=2 m=2
**** begin user architecture code

** IHP models
.lib cornerMOSlv.lib mos_tt
.lib cornerMOShv.lib mos_tt

.lib /opt/pdks/ihp-sg13g2/libs.tech/ngspice/models/cornerRES.lib res_typ

.lib /opt/pdks/ihp-sg13g2/libs.tech/ngspice/models/cornerCAP.lib cap_typ

.param R1=144
.param R2=180
.param C1=80n
.param C2=60n
.param Vin=1.2
.param wn=5.5u
.param ng=36
.param m=45
.param t1=10u
.param t2=20u
.tran 500p 20u
.meas tran i_r1 AVG i(Vamp_1) from=t1 to=t2
.meas tran v_reg_1 AVG v(vout_1) from=t1 to=t2
.meas tran v_reg_2 AVG v(vout_2) from=t1 to=t2
.meas tran p_out_1 AVG par('((v(Vout_1)**2)/R1)') from=t1 to=t2
.meas tran p_out_2 AVG par('((v(Vout_2)**2)/R2)') from=t1 to=t2
.meas tran p_out AVG par('((v(Vout_1)**2)/R1)+((v(Vout_2)**2)/R2)') from=t1 to=t2
.meas tran p_in AVG par('-(v(Vp)-v(Vn))*i(Vin)') from=t1 to=t2
*.meas tran p_d1 AVG par('v(Vout_1)*(i(Vamp_gate1)+i(Vamp_buff1))*2') from=t1 to=t2
*.meas tran p_d2 AVG par('v(Vout_2)*(i(Vamp_gate2)+i(Vamp_buff2))*2') from=t1 to=t2
.meas tran p_id AVG par('v(Vout_2)*i(Vamp_id)') from=t1 to=t2
*.meas tran p_active_diodes param='(p_d1+p_d2)/p_in*100'
.meas tran p_id_percent param='p_id/p_in*100'
.meas tran i_driver1 AVG par('i(Vamp_d1)') from=t1 to=t2
.meas tran i_driver2 AVG par('i(Vamp_d2)') from=t1 to=t2
.meas tran PCE param='p_out/p_in' from=t1 to=t2
.meas tran VCR_1 param='v_reg_1/Vin'
.meas tran VCR_2 param='v_reg_2/Vin'
.save all

**** end user architecture code
.ends

* expanding   symbol:  /shared/designs/SSDOR_1.2V_v3/components/Ibias_uA/CTAT_PTAT/CTAT_PTAT.sym # of pins=10
** sym_path: /shared/designs/SSDOR_1.2V_v3/components/Ibias_uA/CTAT_PTAT/CTAT_PTAT.sym
** sch_path: /shared/designs/SSDOR_1.2V_v3/components/Ibias_uA/CTAT_PTAT/CTAT_PTAT.sch
.subckt CTAT_PTAT VDD GND Ibias_4 Ibias_1 Ibias_2 Ibias_5 Ibias_6 Ibias_3 Vb_0v5 Vb_0v4
*.PININFO VDD:B GND:B Ibias_1:B Ibias_2:B Ibias_3:B Ibias_4:B Ibias_5:B Ibias_6:B Vb_0v4:B Vb_0v5:B
M1 vRPTAT net2 VDD VDD sg13_lv_pmos w=1u l=2u ng=1 m=1
M2 net7 net2 VDD VDD sg13_lv_pmos w=1u l=2u ng=1 m=6
M3 net7 net1 VDD VDD sg13_lv_pmos w=1u l=2u ng=1 m=6
M4 net6 net1 VDD VDD sg13_lv_pmos w=1u l=2u ng=1 m=1
M12 net5 net2 VDD VDD sg13_lv_pmos w=1u l=2u ng=1 m=1
M13 net3 net2 VDD VDD sg13_lv_pmos w=1u l=2u ng=1 m=1
M5 vRCTAT net1 VDD VDD sg13_lv_pmos w=1u l=2u ng=1 m=1
M7 voSCCTP net3 net4 GND sg13_lv_nmos w=0.5u l=1.2u ng=1 m=1
M10 net4 net5 GND GND sg13_lv_nmos w=0.5u l=1.2u ng=1 m=1
M11 net5 net5 net4 GND sg13_lv_nmos w=10u l=0.26u ng=1 m=30
M16 net3 net3 voSCCTP GND sg13_lv_nmos w=10u l=0.26u ng=1 m=30
M30 net7 net7 GND GND sg13_lv_nmos w=1.1u l=2u ng=1 m=3
R2 net9 Vb_0v5 GND rppd w=0.5e-6 l=972.9e-6 m=1 b=0
R6 net10 Vb_0v4 GND rppd w=0.5e-6 l=1167.4e-6 m=1 b=0
R7 Vb_0v4 GND GND rppd w=0.5e-6 l=826e-6 m=1 b=0
R5 Vb_0v5 GND GND rppd w=0.5e-6 l=1024e-6 m=1 b=0
M17 net8 net7 GND GND sg13_lv_nmos w=1.1u l=2u ng=1 m=3
M21 net9 net8 VDD VDD sg13_lv_pmos w=2u l=1u ng=1 m=1
M9 net10 net8 VDD VDD sg13_lv_pmos w=2u l=1u ng=1 m=1
M23 net8 net8 VDD VDD sg13_lv_pmos w=1.1u l=2u ng=1 m=6
M8 Ibias_1 net8 VDD VDD sg13_lv_pmos w=1.1u l=2u ng=1 m=6
M15 Ibias_2 net8 VDD VDD sg13_lv_pmos w=1.1u l=2u ng=1 m=6
M18 Ibias_3 net8 VDD VDD sg13_lv_pmos w=1.1u l=2u ng=1 m=6
M19 Ibias_4 net8 VDD VDD sg13_lv_pmos w=1.1u l=2u ng=1 m=6
M20 Ibias_5 net8 VDD VDD sg13_lv_pmos w=1.1u l=2u ng=1 m=6
M22 Ibias_6 net8 VDD VDD sg13_lv_pmos w=1.1u l=2u ng=1 m=6
M24 GND GND voSCCTN VDD sg13_lv_pmos w=10u l=0.36u ng=1 m=20
M25 voSCCTN GND net6 VDD sg13_lv_pmos w=10u l=0.36u ng=1 m=1
M27 net11 net13 GND GND sg13_lv_nmos w=10u l=1u ng=1 m=1
M29 net12 net14 GND GND sg13_lv_nmos w=10u l=1u ng=1 m=1
R1 vRCTAT net15 GND rppd w=0.5e-6 l=1170e-6 m=1 b=0
R3 net15 GND GND rhigh w=0.5e-6 l=27e-6 m=1 b=0
R10 vRPTAT GND GND rppd w=0.5e-6 l=2110e-6 m=1 b=0
C3 VDD net11 cap_cmim w=26.0e-6 l=26.0e-6 m=1
C1 VDD net12 cap_cmim w=26.0e-6 l=26.0e-6 m=1
M6 net2 net11 net13 GND sg13_lv_nmos w=10u l=1u ng=1 m=1
M14 net1 net12 net14 GND sg13_lv_nmos w=10u l=1u ng=1 m=1
x3 VDD net2 voSCCTP vRPTAT GND Ib_opamp
x1 VDD net1 voSCCTN vRCTAT GND Ib_opamp
C2 net7 GND 3p m=1
C4 VDD net8 10f m=1
.ends

* expanding   symbol:  /shared/designs/SSDOR_1.2V_v3/components/comp_w_hyst/comp_w_hyst.sym # of pins=6
** sym_path: /shared/designs/SSDOR_1.2V_v3/components/comp_w_hyst/comp_w_hyst.sym
** sch_path: /shared/designs/SSDOR_1.2V_v3/components/comp_w_hyst/comp_w_hyst.sch
.subckt comp_w_hyst VDD VSS Vref Vin Vout I_bias
*.PININFO I_bias:I Vref:I Vin:I VSS:B VDD:B Vout:O
M3 net1 net1 VDD VDD sg13_lv_pmos w=0.5u l=0.13u ng=1 m=1
M6 net2 net1 VDD VDD sg13_lv_pmos w=0.5u l=0.13u ng=1 m=1
M7 net1 net2 VDD VDD sg13_lv_pmos w=0.5u l=0.13u ng=1 m=1
M4 net2 net2 VDD VDD sg13_lv_pmos w=0.5u l=0.13u ng=1 m=1
M1 net1 Vref net3 net3 sg13_lv_nmos w=5u l=0.5u ng=1 m=1
M2 net2 Vin net3 net3 sg13_lv_nmos w=5u l=0.5u ng=1 m=1
M5 net3 I_bias VSS VSS sg13_lv_nmos w=1u l=0.5u ng=1 m=1
M9 net5 net1 VDD VDD sg13_lv_pmos w=2u l=0.5u ng=1 m=1
M8 net4 net2 VDD VDD sg13_lv_pmos w=2u l=0.5u ng=1 m=1
M11 net4 net5 VSS VSS sg13_lv_nmos w=1u l=0.5u ng=1 m=1
M10 net5 net5 VSS VSS sg13_lv_nmos w=1u l=0.5u ng=1 m=1
M12 I_bias I_bias VSS VSS sg13_lv_nmos w=1u l=0.5u ng=1 m=1
M13 net6 net4 VSS VSS sg13_lv_nmos w=1u l=0.13u ng=1 m=1
M14 net6 net4 VDD VDD sg13_lv_pmos w=1u l=0.13u ng=1 m=2
M15 net7 net6 VSS VSS sg13_lv_nmos w=2u l=0.13u ng=1 m=1
M16 net7 net6 VDD VDD sg13_lv_pmos w=2u l=0.13u ng=1 m=2
M17 Vout net7 VSS VSS sg13_lv_nmos w=3u l=0.13u ng=1 m=1
M18 Vout net7 VDD VDD sg13_lv_pmos w=3u l=0.13u ng=1 m=2
.ends

* expanding   symbol:  /shared/designs/SSDOR_1.2V_v3/components/logic_controller/logic_controller.sym # of pins=7
** sym_path: /shared/designs/SSDOR_1.2V_v3/components/logic_controller/logic_controller.sym
** sch_path: /shared/designs/SSDOR_1.2V_v3/components/logic_controller/logic_controller.sch
.subckt logic_controller VDD X S1 CLK Y S2 VSS
*.PININFO X:I CLK:I Y:I S1:O S2:O VSS:B VDD:B
M1 net1 X VDD VDD sg13_lv_pmos w=2u l=0.13u ng=1 m=1
M2 net1 CLK VDD VDD sg13_lv_pmos w=2u l=0.13u ng=1 m=1
M3 net1 X net3 VSS sg13_lv_nmos w=1u l=0.13u ng=1 m=1
M4 net3 CLK VSS VSS sg13_lv_nmos w=1u l=0.13u ng=1 m=1
M5 S1 net1 VDD VDD sg13_lv_pmos w=2u l=0.13u ng=1 m=1
M6 S1 net1 VSS VSS sg13_lv_nmos w=1u l=0.13u ng=1 m=1
M7 net2 Y VDD VDD sg13_lv_pmos w=2u l=0.13u ng=1 m=1
M8 net2 Y VSS VSS sg13_lv_nmos w=1u l=0.13u ng=1 m=1
M9 net4 net2 VDD VDD sg13_lv_pmos w=2u l=0.13u ng=1 m=1
M10 S2 CLK net4 VDD sg13_lv_pmos w=2u l=0.13u ng=1 m=1
M11 S2 net2 VSS VSS sg13_lv_nmos w=1u l=0.13u ng=1 m=1
M12 S2 CLK VSS VSS sg13_lv_nmos w=1u l=0.13u ng=1 m=1
.ends

* expanding   symbol:  /shared/designs/SSDOR_1.2V_v3/components/logic_shift_down_v1/logic_shift_down_v1.sym # of pins=4
** sym_path: /shared/designs/SSDOR_1.2V_v3/components/logic_shift_down_v1/logic_shift_down_v1.sym
** sch_path: /shared/designs/SSDOR_1.2V_v3/components/logic_shift_down_v1/logic_shift_down_v1.sch
.subckt logic_shift_down_v1 VDDL IN OUT VSS
*.PININFO IN:I OUT:O VDDL:B VSS:B
M1 net1 IN VDDL VDDL sg13_lv_pmos w=2u l=0.13u ng=1 m=1
M2 net1 IN VSS VSS sg13_lv_nmos w=1u l=0.13u ng=1 m=1
M3 OUT net1 VDDL VDDL sg13_lv_pmos w=2u l=0.13u ng=1 m=1
M4 OUT net1 VSS VSS sg13_lv_nmos w=1u l=0.13u ng=1 m=1
.ends

* expanding   symbol:  /shared/designs/SSDOR_1.2V_v3/components/pmos_comp/pmos_comp.sym # of pins=5
** sym_path: /shared/designs/SSDOR_1.2V_v3/components/pmos_comp/pmos_comp.sym
** sch_path: /shared/designs/SSDOR_1.2V_v3/components/pmos_comp/pmos_comp.sch
.subckt pmos_comp Vin- Vin+ Vout I_bias VSS
*.PININFO I_bias:I Vin-:I Vin+:I VSS:I Vout:O
M1 net2 net1 Vin- Vin- sg13_lv_pmos w=4u l=0.5u ng=1 m=1
M2 net1 net1 Vin+ Vin+ sg13_lv_pmos w=4u l=0.5u ng=1 m=1
M3 Vout net3 Vin+ Vin+ sg13_lv_pmos w=4u l=0.5u ng=1 m=1
M4 net3 net3 Vin- Vin- sg13_lv_pmos w=4u l=0.5u ng=1 m=1
M5 net2 net2 VSS VSS sg13_lv_nmos w=1u l=0.5u ng=1 m=1
M6 Vout net2 VSS VSS sg13_lv_nmos w=1u l=0.5u ng=1 m=1
M8 net1 I_bias VSS VSS sg13_lv_nmos w=1u l=0.5u ng=1 m=1
M7 I_bias I_bias VSS VSS sg13_lv_nmos w=1u l=0.5u ng=1 m=1
M9 net3 I_bias VSS VSS sg13_lv_nmos w=1u l=0.5u ng=1 m=1
.ends

* expanding   symbol:  /shared/designs/SSDOR_1.2V_v3/components/mux/mux.sym # of pins=6
** sym_path: /shared/designs/SSDOR_1.2V_v3/components/mux/mux.sym
** sch_path: /shared/designs/SSDOR_1.2V_v3/components/mux/mux.sch
.subckt mux VDD IN0 S OUT IN1 VSS
*.PININFO S:I IN0:I IN1:I OUT:O VDD:B VSS:B
M1 IN0 net1 OUT VSS sg13_lv_nmos w=1u l=0.13u ng=1 m=1
M2 IN0 S OUT VDD sg13_lv_pmos w=2u l=0.13u ng=1 m=1
M3 IN1 S OUT VSS sg13_lv_nmos w=1u l=0.13u ng=1 m=1
M4 IN1 net1 OUT VDD sg13_lv_pmos w=2u l=0.13u ng=1 m=1
x1 VSS S net1 VDD mux_inverter
.ends

* expanding   symbol:  /shared/designs/SSDOR_1.2V_v3/components/buffer/buffer.sym # of pins=4
** sym_path: /shared/designs/SSDOR_1.2V_v3/components/buffer/buffer.sym
** sch_path: /shared/designs/SSDOR_1.2V_v3/components/buffer/buffer.sch
.subckt buffer VDD IN OUT VSS  wn=1u
*.PININFO VDD:B VSS:B IN:I OUT:O
M1 net1 IN VSS VSS sg13_lv_nmos w=wn l=0.13u ng=1 m=1
M2 net1 IN VDD VDD sg13_lv_pmos w=wn l=0.13u ng=1 m=2
M3 net2 net1 VSS VSS sg13_lv_nmos w=wn l=0.13u ng=1 m=2
M4 net2 net1 VDD VDD sg13_lv_pmos w=wn l=0.13u ng=1 m=2*2
M5 net3 net2 VSS VSS sg13_lv_nmos w=wn l=0.13u ng=1 m=8
M6 net3 net2 VDD VDD sg13_lv_pmos w=wn l=0.13u ng=1 m=2*8
M8 OUT net3 VDD VDD sg13_lv_pmos w=wn l=0.13u ng=1 m=2*27
M7 OUT net3 VSS VSS sg13_lv_nmos w=wn l=0.13u ng=1 m=27
.ends

* expanding   symbol:  /shared/designs/SSDOR_1.2V_v3/components/cgenerator/cgenerator.sym # of pins=3
** sym_path: /shared/designs/SSDOR_1.2V_v3/components/cgenerator/cgenerator.sym
** sch_path: /shared/designs/SSDOR_1.2V_v3/components/cgenerator/cgenerator.sch
.subckt cgenerator vdd vout vss
*.PININFO vdd:B vss:B vout:O
xi1 vdd net1 net9 vss inv_ring_osc
xi2 vdd net9 net8 vss inv_ring_osc
xi3 vdd net8 net7 vss inv_ring_osc
xi4 vdd net7 net6 vss inv_ring_osc
xi5 vdd net6 net5 vss inv_ring_osc
xi6 vdd net5 net4 vss inv_ring_osc
xi7 vdd net4 net3 vss inv_ring_osc
xi8 vdd net3 net2 vss inv_ring_osc
xi9 vdd net2 net11 vss inv_ring_osc
xi10 vdd net11 net10 vss inv_ring_osc
xi11 vdd net10 net1 vss inv_ring_osc
x1 vdd net1 vout vss buff_ring_osc
.ends

* expanding   symbol:  /shared/designs/Layouts/PMOS/pmos_array.sym # of pins=4
** sym_path: /shared/designs/Layouts/PMOS/pmos_array.sym
** sch_path: /shared/designs/Layouts/PMOS/pmos_array.sch
.subckt pmos_array Vs_array Vg_array Vb_array Vd_array
*.PININFO Vg_array:I Vs_array:B Vd_array:B Vb_array:B
M2 Vd_array Vg_array Vs_array net1 sg13_lv_pmos w=86.4u l=0.13u ng=36 m=1
M3 Vd_array Vg_array Vs_array net1 sg13_lv_pmos w=86.4u l=0.13u ng=36 m=1
M4 Vd_array Vg_array Vs_array net1 sg13_lv_pmos w=86.4u l=0.13u ng=36 m=1
M5 Vd_array Vg_array Vs_array net1 sg13_lv_pmos w=86.4u l=0.13u ng=36 m=1
M6 Vd_array Vg_array Vs_array net1 sg13_lv_pmos w=86.4u l=0.13u ng=36 m=1
M7 Vd_array Vg_array Vs_array net1 sg13_lv_pmos w=86.4u l=0.13u ng=36 m=1
M8 Vd_array Vg_array Vs_array net1 sg13_lv_pmos w=86.4u l=0.13u ng=36 m=1
M9 Vd_array Vg_array Vs_array net1 sg13_lv_pmos w=86.4u l=0.13u ng=36 m=1
M10 Vd_array Vg_array Vs_array net1 sg13_lv_pmos w=86.4u l=0.13u ng=36 m=1
M11 Vd_array Vg_array Vs_array net1 sg13_lv_pmos w=86.4u l=0.13u ng=36 m=1
M12 Vd_array Vg_array Vs_array net1 sg13_lv_pmos w=86.4u l=0.13u ng=36 m=1
M13 Vd_array Vg_array Vs_array net1 sg13_lv_pmos w=86.4u l=0.13u ng=36 m=1
M14 Vd_array Vg_array Vs_array net1 sg13_lv_pmos w=86.4u l=0.13u ng=36 m=1
M15 Vd_array Vg_array Vs_array net1 sg13_lv_pmos w=86.4u l=0.13u ng=36 m=1
M16 Vd_array Vg_array Vs_array net1 sg13_lv_pmos w=86.4u l=0.13u ng=36 m=1
M17 Vd_array Vg_array Vs_array net1 sg13_lv_pmos w=86.4u l=0.13u ng=36 m=1
R9 Vb_array net1 ntap1 R=1.116 w=1e-6 l=292e-6
R1 Vb_array net1 ntap1 R=1.116 w=1e-6 l=292e-6
R2 Vb_array net1 ntap1 R=1.116 w=1e-6 l=292e-6
R3 Vb_array net1 ntap1 R=1.116 w=1e-6 l=292e-6
R4 Vb_array net1 ntap1 R=1.116 w=1e-6 l=292e-6
R5 Vb_array net1 ntap1 R=1.116 w=1e-6 l=292e-6
R6 Vb_array net1 ntap1 R=1.116 w=1e-6 l=292e-6
R7 Vb_array net1 ntap1 R=1.116 w=1e-6 l=292e-6
R8 Vb_array net1 ntap1 R=1.116 w=1e-6 l=292e-6
.ends

* expanding   symbol:  /shared/designs/SSDOR_1.2V_v3/components/Ibias_uA/ibias_opamp/Ib_opamp.sym # of pins=5
** sym_path: /shared/designs/SSDOR_1.2V_v3/components/Ibias_uA/ibias_opamp/Ib_opamp.sym
** sch_path: /shared/designs/SSDOR_1.2V_v3/components/Ibias_uA/ibias_opamp/Ib_opamp.sch
.subckt Ib_opamp VDD Vout V- V+ GND
*.PININFO VDD:B V+:I V-:I GND:B Vout:O
M4 net1 V+ GND GND sg13_lv_nmos w=10u l=8u ng=1 m=6
M5 net1 net1 VDD VDD sg13_lv_pmos w=10u l=0.5u ng=1 m=4
M7 Vout net1 VDD VDD sg13_lv_pmos w=10u l=0.5u ng=1 m=4
M8 Vout V- GND GND sg13_lv_nmos w=10u l=8u ng=1 m=6
.ends

* expanding   symbol:  /shared/designs/SSDOR_1.2V_v3/components/mux/mux_inverter/mux_inverter.sym # of pins=4
** sym_path: /shared/designs/SSDOR_1.2V_v3/components/mux/mux_inverter/mux_inverter.sym
** sch_path: /shared/designs/SSDOR_1.2V_v3/components/mux/mux_inverter/mux_inverter.sch
.subckt mux_inverter VSS IN OUT VDD
*.PININFO IN:I OUT:O VSS:B VDD:B
M1 OUT IN VSS VSS sg13_lv_nmos w=0.5u l=0.13u ng=1 m=1
M2 OUT IN VDD VDD sg13_lv_pmos w=1u l=0.13u ng=1 m=1
.ends

* expanding   symbol:  /shared/designs/SSDOR_1.2V_v3/components/cgenerator/inv_ring_osc.sym # of pins=4
** sym_path: /shared/designs/SSDOR_1.2V_v3/components/cgenerator/inv_ring_osc.sym
** sch_path: /shared/designs/SSDOR_1.2V_v3/components/cgenerator/inv_ring_osc.sch
.subckt inv_ring_osc vdd in out vss
*.PININFO vdd:B vss:B in:I out:O
M1 out in vss vss sg13_lv_nmos w=2u l=1u ng=1 m=1
M2 out in vdd vdd sg13_lv_pmos w=4u l=1u ng=1 m=1
.ends

* expanding   symbol:  /shared/designs/SSDOR_1.2V_v3/components/cgenerator/buff_ring_osc.sym # of pins=4
** sym_path: /shared/designs/SSDOR_1.2V_v3/components/cgenerator/buff_ring_osc.sym
** sch_path: /shared/designs/SSDOR_1.2V_v3/components/cgenerator/buff_ring_osc.sch
.subckt buff_ring_osc vdd in out vss
*.PININFO in:I vdd:B vss:B out:O
M1 net1 in vss vss sg13_lv_nmos w=2u l=0.13u ng=1 m=1
M2 net1 in vdd vdd sg13_lv_pmos w=4u l=0.13u ng=1 m=1
M3 out net1 vdd vdd sg13_lv_pmos w=8u l=0.13u ng=2 m=1
M4 out net1 vss vss sg13_lv_nmos w=4u l=0.13u ng=2 m=1
.ends

.GLOBAL GND
