** sch_path: /shared/designs/Layouts/PMOS/nmos_array.sch
.subckt nmos_array Vd_array Vg_array Vs_array Vb_array
*.PININFO Vd_array:B Vg_array:I Vs_array:B Vb_array:B
M2 Vd_array Vg_array Vs_array net1 sg13_lv_nmos w=86.4u l=0.13u ng=36 m=1
R2 Vb_array net1 ptap1 A=2.13e-10 P=0.000428
M1 Vd_array Vg_array Vs_array net1 sg13_lv_nmos w=86.4u l=0.13u ng=36 m=1
M3 Vd_array Vg_array Vs_array net1 sg13_lv_nmos w=86.4u l=0.13u ng=36 m=1
M4 Vd_array Vg_array Vs_array net1 sg13_lv_nmos w=86.4u l=0.13u ng=36 m=1
M5 Vd_array Vg_array Vs_array net1 sg13_lv_nmos w=86.4u l=0.13u ng=36 m=1
M6 Vd_array Vg_array Vs_array net1 sg13_lv_nmos w=86.4u l=0.13u ng=36 m=1
M7 Vd_array Vg_array Vs_array net1 sg13_lv_nmos w=86.4u l=0.13u ng=36 m=1
M8 Vd_array Vg_array Vs_array net1 sg13_lv_nmos w=86.4u l=0.13u ng=36 m=1
M9 Vd_array Vg_array Vs_array net1 sg13_lv_nmos w=86.4u l=0.13u ng=36 m=1
R1 Vb_array net1 ptap1 A=2.13e-10 P=0.000428
R3 Vb_array net1 ptap1 A=2.13e-10 P=0.000428
R4 Vb_array net1 ptap1 A=2.13e-10 P=0.000428
R5 Vb_array net1 ptap1 A=2.13e-10 P=0.000428
R6 Vb_array net1 ptap1 A=2.13e-10 P=0.000428
R7 Vb_array net1 ptap1 A=2.13e-10 P=0.000428
.ends
