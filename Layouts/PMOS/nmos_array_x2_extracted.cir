* Extracted by KLayout with SG13G2 LVS runset on : 01/04/2026 06:04

.SUBCKT nmos_array_x2 VS_ARRAY VD_ARRAY_L VB_ARRAY VD_ARRAY_R
M$1 VD_ARRAY_L VD_ARRAY_R VS_ARRAY \$1 sg13_lv_nmos L=0.13u W=777.6u
+ AS=294.192p AD=294.192p PS=3922.56u PD=3922.56u
M$2629 VD_ARRAY_R VD_ARRAY_L VS_ARRAY \$1 sg13_lv_nmos L=0.13u W=777.6u
+ AS=294.192p AD=294.192p PS=3922.56u PD=3922.56u
R$10369 \$1 VB_ARRAY ptap1 A=2982p P=5992u
.ENDS nmos_array_x2
