* Extracted by KLayout with SG13G2 LVS runset on : 02/04/2026 06:20

.SUBCKT pmos_body_bias VD_ARRAY VS_ARRAY VG_ARRAY
M$1 VS_ARRAY VG_ARRAY VD_ARRAY \$6 sg13_lv_pmos L=0.13u W=1382.4u AS=523.104p
+ AD=523.056p PS=6974.08u PD=6973.76u
R$9217 \$8 \$10 ntap1 A=3.5p P=11.4u
R$9218 \$6 \$10 ntap1 A=2628p P=5274u
M$9227 \$10 VD_ARRAY VS_ARRAY \$8 sg13_lv_pmos L=0.13u W=9u AS=3.06p AD=3.06p
+ PS=18.68u PD=18.68u
M$9228 \$10 VS_ARRAY VD_ARRAY \$8 sg13_lv_pmos L=0.13u W=3u AS=1.02p AD=1.02p
+ PS=6.68u PD=6.68u
.ENDS pmos_body_bias
