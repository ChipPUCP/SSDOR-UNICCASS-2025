** sch_path: /home/designer/shared/designs/SSDOR_1.2V_v3/components/comp_w_hyst/inverters.sch
.subckt inverters vss vdd1 vdd2 vx1 vx2
*.PININFO vss:B vdd1:B vdd2:B vx1:O vx2:O
MM21 vx1 vx1 vdd1 well1 sg13_lv_pmos w=0.5u l=10u ng=1 m=19
MM22 vx1 vx1 vss vss sg13_lv_nmos w=0.5u l=10u ng=1 m=1
MM23 vx2 vx2 vdd2 well2 sg13_lv_pmos w=0.5u l=10u ng=1 m=10
MM24 vx2 vx2 vss vss sg13_lv_nmos w=0.5u l=10u ng=1 m=1
RR1 vdd1 well1 ntap1 A=1e-11 P=2.2e-05
RR2 vdd2 well2 ntap1 A=1e-11 P=2.2e-05
.ends
