* Extracted by KLayout with SG13G2 LVS runset on : 03/04/2026 00:21

.SUBCKT buffer VSS OUT IN VDD
M$1 VSS \$5 OUT VSS sg13_lv_nmos L=0.13u W=27u AS=9.18p AD=9.18p PS=72.36u
+ PD=72.36u rfmode=0
M$15 VSS \$11 \$5 VSS sg13_lv_nmos L=0.13u W=8u AS=2.72p AD=2.72p PS=21.44u
+ PD=21.44u rfmode=0
M$23 VSS \$22 \$11 VSS sg13_lv_nmos L=0.13u W=2u AS=0.53p AD=0.53p PS=4.06u
+ PD=4.06u rfmode=0
M$25 VSS IN \$22 VSS sg13_lv_nmos L=0.13u W=1u AS=0.34p AD=0.34p PS=2.68u
+ PD=2.68u rfmode=0
M$39 VDD \$11 \$5 \$27 sg13_lv_pmos L=0.13u W=16u AS=5.44p AD=5.44p PS=42.88u
+ PD=42.88u rfmode=0
M$47 VDD \$5 OUT \$27 sg13_lv_pmos L=0.13u W=54u AS=18.36p AD=18.36p PS=144.72u
+ PD=144.72u rfmode=0
M$49 VDD IN \$22 \$27 sg13_lv_pmos L=0.13u W=2u AS=0.68p AD=0.68p PS=5.36u
+ PD=5.36u rfmode=0
M$61 VDD \$22 \$11 \$27 sg13_lv_pmos L=0.13u W=4u AS=1.06p AD=1.06p PS=8.12u
+ PD=8.12u rfmode=0
R$115 VDD \$27 ntap1 A=106p P=218u
.ENDS buffer
