** sch_path: /home/designer/shared/designs/SSDOR_1.2V_v3/components/logic_controller/logic_controller.sch
.subckt logic_controller VDD X S1 CLK Y S2 VSS
*.PININFO X:I CLK:I Y:I S1:O S2:O VSS:B VDD:B
MM1 net1 X VDD well sg13_lv_pmos w=2u l=0.13u ng=1 m=1
MM2 net1 CLK VDD well sg13_lv_pmos w=2u l=0.13u ng=1 m=1
MM3 net1 X net3 VSS sg13_lv_nmos w=1u l=0.13u ng=1 m=1
MM4 net3 CLK VSS VSS sg13_lv_nmos w=1u l=0.13u ng=1 m=1
MM5 S1 net1 VDD well sg13_lv_pmos w=2u l=0.13u ng=1 m=1
MM6 S1 net1 VSS VSS sg13_lv_nmos w=1u l=0.13u ng=1 m=1
MM7 net2 Y VDD well sg13_lv_pmos w=2u l=0.13u ng=1 m=1
MM8 net2 Y VSS VSS sg13_lv_nmos w=1u l=0.13u ng=1 m=1
MM9 net4 net2 VDD well sg13_lv_pmos w=2u l=0.13u ng=1 m=1
MM10 S2 CLK net4 well sg13_lv_pmos w=2u l=0.13u ng=1 m=1
MM11 S2 net2 VSS VSS sg13_lv_nmos w=1u l=0.13u ng=1 m=1
MM12 S2 CLK VSS VSS sg13_lv_nmos w=1u l=0.13u ng=1 m=1
RR1 VDD well ntap1 A=7e-12 P=1.6e-05
.ends
