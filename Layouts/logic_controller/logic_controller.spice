** sch_path: /home/designer/shared/designs/SSDOR_1.2V_v3/components/logic_controller/logic_controller.sch
.subckt logic_controller VDD X S1 CLK Y S2 VSS
*.PININFO X:I CLK:I Y:I S1:O S2:O VSS:B VDD:B
M1 net1 X VDD VDD sg13_lv_pmos w=2u l=0.13u ng=1 m=1
M2 net1 CLK VDD VDD sg13_lv_pmos w=2u l=0.13u ng=1 m=1
M3 net1 X net3 VSS sg13_lv_nmos w=1u l=0.13u ng=1 m=1
M4 net3 CLK VSS VSS sg13_lv_nmos w=1u l=0.13u ng=1 m=1
M5 S1 net1 VDD VDD sg13_lv_pmos w=2u l=0.13u ng=1 m=1
M6 S1 net1 VSS VSS sg13_lv_nmos w=1u l=0.13u ng=1 m=1
M7 net2 Y VDD VDD sg13_lv_pmos w=2u l=0.13u ng=1 m=1
M8 net2 Y VSS VSS sg13_lv_nmos w=1u l=0.13u ng=1 m=1
M9 net4 net2 VDD VDD sg13_lv_pmos w=2u l=0.13u ng=1 m=1
M10 S2 CLK net4 VDD sg13_lv_pmos w=2u l=0.13u ng=1 m=1
M11 S2 net2 VSS VSS sg13_lv_nmos w=1u l=0.13u ng=1 m=1
M12 S2 CLK VSS VSS sg13_lv_nmos w=1u l=0.13u ng=1 m=1
.ends
