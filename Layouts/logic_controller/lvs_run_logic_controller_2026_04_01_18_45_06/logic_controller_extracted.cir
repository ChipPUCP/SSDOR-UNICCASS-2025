* Extracted by KLayout with SG13G2 LVS runset on : 01/04/2026 18:45

.SUBCKT logic_controller VSS X S2 S1 Y CLK VDD
M$1 VSS \$5 S1 VSS sg13_lv_nmos L=0.13u W=1u AS=0.34p AD=0.34p PS=2.68u
+ PD=2.68u rfmode=0
M$2 VSS CLK \$13 VSS sg13_lv_nmos L=0.13u W=1u AS=0.34p AD=0.19p PS=2.68u
+ PD=1.38u rfmode=0
M$3 \$13 X \$5 VSS sg13_lv_nmos L=0.13u W=1u AS=0.19p AD=0.36p PS=1.38u
+ PD=2.72u rfmode=0
M$4 VSS \$3 S2 VSS sg13_lv_nmos L=0.13u W=1u AS=0.34p AD=0.19p PS=2.68u
+ PD=1.38u rfmode=0
M$5 S2 CLK VSS VSS sg13_lv_nmos L=0.13u W=1u AS=0.19p AD=0.36p PS=1.38u
+ PD=2.72u rfmode=0
M$6 VSS Y \$3 VSS sg13_lv_nmos L=0.13u W=1u AS=0.34p AD=0.34p PS=2.68u PD=2.68u
+ rfmode=0
M$7 VDD \$5 S1 \$7 sg13_lv_pmos L=0.13u W=2u AS=0.68p AD=0.68p PS=4.68u
+ PD=4.68u rfmode=0
M$8 VDD CLK \$5 \$7 sg13_lv_pmos L=0.13u W=2u AS=0.68p AD=0.38p PS=4.68u
+ PD=2.38u rfmode=0
M$9 \$5 X VDD \$7 sg13_lv_pmos L=0.13u W=2u AS=0.38p AD=0.72p PS=2.38u PD=4.72u
+ rfmode=0
M$10 VDD Y \$3 \$7 sg13_lv_pmos L=0.13u W=2u AS=0.68p AD=0.68p PS=4.68u
+ PD=4.68u rfmode=0
M$11 VDD \$3 \$16 \$7 sg13_lv_pmos L=0.13u W=2u AS=0.68p AD=0.38p PS=4.68u
+ PD=2.38u rfmode=0
M$12 \$16 CLK S2 \$7 sg13_lv_pmos L=0.13u W=2u AS=0.38p AD=0.72p PS=2.38u
+ PD=4.72u rfmode=0
R$13 VDD \$7 ntap1 A=7p P=16u
.ENDS logic_controller
