* Extracted by KLayout with SG13G2 LVS runset on : 18/03/2026 04:10

.SUBCKT logic_controller VSS S2 S1 Y CLK X VDD
M$1 VSS \$4 S1 VSS sg13_lv_nmos L=0.13u W=1u AS=0.34p AD=0.34p PS=2.68u PD=2.68u
M$2 VSS CLK \$6 VSS sg13_lv_nmos L=0.13u W=1u AS=0.34p AD=0.19p PS=2.68u
+ PD=1.38u
M$3 \$6 X \$4 VSS sg13_lv_nmos L=0.13u W=1u AS=0.19p AD=0.36p PS=1.38u PD=2.72u
M$4 VSS \$2 S2 VSS sg13_lv_nmos L=0.13u W=1u AS=0.34p AD=0.19p PS=2.68u PD=1.38u
M$5 S2 CLK VSS VSS sg13_lv_nmos L=0.13u W=1u AS=0.19p AD=0.36p PS=1.38u PD=2.72u
M$6 VSS Y \$2 VSS sg13_lv_nmos L=0.13u W=1u AS=0.34p AD=0.34p PS=2.68u PD=2.68u
M$7 VDD \$4 S1 VDD sg13_lv_pmos L=0.13u W=2u AS=0.68p AD=0.68p PS=4.68u PD=4.68u
M$8 VDD CLK \$4 VDD sg13_lv_pmos L=0.13u W=2u AS=0.68p AD=0.38p PS=4.68u
+ PD=2.38u
M$9 \$4 X VDD VDD sg13_lv_pmos L=0.13u W=2u AS=0.38p AD=0.72p PS=2.38u PD=4.72u
M$10 VDD \$2 \$12 VDD sg13_lv_pmos L=0.13u W=2u AS=0.68p AD=0.38p PS=4.68u
+ PD=2.38u
M$11 \$12 CLK S2 VDD sg13_lv_pmos L=0.13u W=2u AS=0.38p AD=0.72p PS=2.38u
+ PD=4.72u
M$12 VDD Y \$2 VDD sg13_lv_pmos L=0.13u W=2u AS=0.68p AD=0.68p PS=4.68u PD=4.68u
.ENDS logic_controller
