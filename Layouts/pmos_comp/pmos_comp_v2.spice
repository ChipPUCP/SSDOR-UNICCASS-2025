** sch_path: /home/designer/shared/designs/SSDOR_1.2V_v3/components/pmos_comp/pmos_comp_v2.sch
.subckt pmos_comp_v2 Vin- Vin+ Vout I_bias VSS
*.PININFO I_bias:I Vin-:I Vin+:I VSS:I Vout:O
M1 net2 net1 Vin- well3 sg13_lv_pmos w=4u l=0.5u ng=1 m=1
M2 net1 net1 Vin+ well1 sg13_lv_pmos w=4u l=0.5u ng=1 m=1
M3 Vout net3 Vin+ well1 sg13_lv_pmos w=4u l=0.5u ng=1 m=1
M4 net3 net3 Vin- well2 sg13_lv_pmos w=4u l=0.5u ng=1 m=1
M5 net2 net2 VSS sub! sg13_lv_nmos w=1u l=0.5u ng=1 m=1
M6 Vout net2 VSS sub! sg13_lv_nmos w=1u l=0.5u ng=1 m=1
M8 net1 I_bias VSS sub! sg13_lv_nmos w=1u l=0.5u ng=1 m=1
M7 I_bias I_bias VSS sub! sg13_lv_nmos w=1u l=0.5u ng=1 m=1
M9 net3 I_bias VSS sub! sg13_lv_nmos w=1u l=0.5u ng=1 m=1
R1 Vin+ well1 ntap1 A=1.56e-12 P=5.56e-06
R4 VSS sub! ptap1 A=1.2e-11 P=2.6e-05
R2 Vin- well2 ntap1 A=7.8e-13 P=3.56e-06
R3 Vin- well3 ntap1 A=7.8e-13 P=3.56e-06
.ends
