** sch_path: /shared/designs/Layouts/Dig_control/dig_control.sch
.subckt dig_control Vb0v4 VSS Vout_2 Vb0v5 Ibias_5 Ibias_6 S2 S1 Vout_1
*.PININFO Vb0v4:I VSS:B Vout_2:B Vb0v5:I Ibias_5:I Ibias_6:I S2:O S1:O Vout_1:B
M3 net1 net1 Vout_2 wellb1 sg13_lv_pmos w=0.5u l=0.13u ng=1 m=1
M6 net2 net1 Vout_2 wellb1 sg13_lv_pmos w=0.5u l=0.13u ng=1 m=1
M7 net1 net2 Vout_2 wellb1 sg13_lv_pmos w=0.5u l=0.13u ng=1 m=1
M4 net2 net2 Vout_2 wellb1 sg13_lv_pmos w=0.5u l=0.13u ng=1 m=1
M1 net1 Vb0v4 net5 pt_well sg13_lv_nmos w=5u l=0.5u ng=1 m=1
M2 net2 Vx1 net5 pt_well sg13_lv_nmos w=5u l=0.5u ng=1 m=1
M5 net5 Ibias_5 VSS pt_well sg13_lv_nmos w=1u l=0.5u ng=1 m=1
M9 net4 net1 Vout_2 wellb1 sg13_lv_pmos w=2u l=0.5u ng=1 m=1
M8 net3 net2 Vout_2 wellb1 sg13_lv_pmos w=2u l=0.5u ng=1 m=1
M11 net3 net4 VSS pt_well sg13_lv_nmos w=1u l=0.5u ng=1 m=1
M10 net4 net4 VSS pt_well sg13_lv_nmos w=1u l=0.5u ng=1 m=1
M12 Ibias_5 Ibias_5 VSS pt_well sg13_lv_nmos w=1u l=0.5u ng=1 m=1
M13 net6 net3 VSS pt_well sg13_lv_nmos w=1u l=0.13u ng=1 m=1
M14 net6 net3 Vout_2 wellb1 sg13_lv_pmos w=1u l=0.13u ng=1 m=2
M15 net7 net6 VSS pt_well sg13_lv_nmos w=2u l=0.13u ng=1 m=1
M16 net7 net6 Vout_2 wellb1 sg13_lv_pmos w=2u l=0.13u ng=1 m=2
M17 X net7 VSS pt_well sg13_lv_nmos w=3u l=0.13u ng=1 m=1
M18 X net7 Vout_2 wellb1 sg13_lv_pmos w=3u l=0.13u ng=1 m=2
M19 net8 net8 Vout_2 wellb1 sg13_lv_pmos w=0.5u l=0.13u ng=1 m=1
M20 net9 net8 Vout_2 wellb1 sg13_lv_pmos w=0.5u l=0.13u ng=1 m=1
M21 net8 net9 Vout_2 wellb1 sg13_lv_pmos w=0.5u l=0.13u ng=1 m=1
M22 net9 net9 Vout_2 wellb1 sg13_lv_pmos w=0.5u l=0.13u ng=1 m=1
M23 net8 Vb0v5 net12 pt_well sg13_lv_nmos w=5u l=0.5u ng=1 m=1
M24 net9 Vx2 net12 pt_well sg13_lv_nmos w=5u l=0.5u ng=1 m=1
M25 net12 Ibias_6 VSS pt_well sg13_lv_nmos w=1u l=0.5u ng=1 m=1
M26 net11 net8 Vout_2 wellb1 sg13_lv_pmos w=2u l=0.5u ng=1 m=1
M27 net10 net9 Vout_2 wellb1 sg13_lv_pmos w=2u l=0.5u ng=1 m=1
M28 net10 net11 VSS pt_well sg13_lv_nmos w=1u l=0.5u ng=1 m=1
M29 net11 net11 VSS pt_well sg13_lv_nmos w=1u l=0.5u ng=1 m=1
M30 Ibias_6 Ibias_6 VSS pt_well sg13_lv_nmos w=1u l=0.5u ng=1 m=1
M31 net13 net10 VSS pt_well sg13_lv_nmos w=1u l=0.13u ng=1 m=1
M32 net13 net10 Vout_2 wellb1 sg13_lv_pmos w=1u l=0.13u ng=1 m=2
M33 net14 net13 VSS pt_well sg13_lv_nmos w=2u l=0.13u ng=1 m=1
M34 net14 net13 Vout_2 wellb1 sg13_lv_pmos w=2u l=0.13u ng=1 m=2
M35 Y net14 VSS pt_well sg13_lv_nmos w=3u l=0.13u ng=1 m=1
M36 Y net14 Vout_2 wellb1 sg13_lv_pmos w=3u l=0.13u ng=1 m=2
M37 Vx1 Vx1 Vout_1 wellu sg13_lv_pmos w=0.5u l=10u ng=1 m=19
M38 Vx1 Vx1 VSS pt_well sg13_lv_nmos w=0.5u l=10u ng=1 m=1
M39 Vx2 Vx2 Vout_2 welld sg13_lv_pmos w=0.5u l=10u ng=1 m=10
M40 Vx2 Vx2 VSS pt_well sg13_lv_nmos w=0.5u l=10u ng=1 m=1
R1 Vout_2 wellb1 ntap1 A=1.2e-11 P=2.6e-05
R2 Vout_2 wellb1 ntap1 A=1.2e-11 P=2.6e-05
R3 Vout_1 wellu ntap1 A=1e-11 P=2.2e-05
R4 Vout_2 welld ntap1 A=1e-11 P=2.2e-05
M41 net15 net16 VSS pt_well sg13_lv_nmos w=2u l=1u ng=1 m=1
M42 net15 net16 Vout_2 well sg13_lv_pmos w=4u l=1u ng=1 m=1
M43 net17 net15 VSS pt_well sg13_lv_nmos w=2u l=1u ng=1 m=1
M44 net17 net15 Vout_2 well sg13_lv_pmos w=4u l=1u ng=1 m=1
M45 net18 net17 VSS pt_well sg13_lv_nmos w=2u l=1u ng=1 m=1
M46 net18 net17 Vout_2 well sg13_lv_pmos w=4u l=1u ng=1 m=1
M47 net19 net18 VSS pt_well sg13_lv_nmos w=2u l=1u ng=1 m=1
M48 net19 net18 Vout_2 well sg13_lv_pmos w=4u l=1u ng=1 m=1
M49 net20 net19 VSS pt_well sg13_lv_nmos w=2u l=1u ng=1 m=1
M50 net20 net19 Vout_2 well sg13_lv_pmos w=4u l=1u ng=1 m=1
M51 net21 net20 VSS pt_well sg13_lv_nmos w=2u l=1u ng=1 m=1
M52 net21 net20 Vout_2 well sg13_lv_pmos w=4u l=1u ng=1 m=1
M53 net22 net21 VSS pt_well sg13_lv_nmos w=2u l=1u ng=1 m=1
M54 net22 net21 Vout_2 well sg13_lv_pmos w=4u l=1u ng=1 m=1
M55 net23 net22 VSS pt_well sg13_lv_nmos w=2u l=1u ng=1 m=1
M56 net23 net22 Vout_2 well sg13_lv_pmos w=4u l=1u ng=1 m=1
M57 net24 net23 VSS pt_well sg13_lv_nmos w=2u l=1u ng=1 m=1
M58 net24 net23 Vout_2 well sg13_lv_pmos w=4u l=1u ng=1 m=1
M59 net25 net24 VSS pt_well sg13_lv_nmos w=2u l=1u ng=1 m=1
M60 net25 net24 Vout_2 well sg13_lv_pmos w=4u l=1u ng=1 m=1
M61 net16 net25 VSS pt_well sg13_lv_nmos w=2u l=1u ng=1 m=1
M62 net16 net25 Vout_2 well sg13_lv_pmos w=4u l=1u ng=1 m=1
M63 net26 net16 VSS pt_well sg13_lv_nmos w=2u l=0.13u ng=1 m=1
M64 net26 net16 Vout_2 well sg13_lv_pmos w=4u l=0.13u ng=1 m=1
M65 net27 net26 Vout_2 well sg13_lv_pmos w=8u l=0.13u ng=2 m=1
M66 net27 net26 VSS pt_well sg13_lv_nmos w=4u l=0.13u ng=2 m=1
R5 Vout_2 well ntap1 A=2.9e-11 P=6e-05
M67 net29 X Vout_2 well sg13_lv_pmos w=2u l=0.13u ng=1 m=1
M68 net29 net27 Vout_2 well sg13_lv_pmos w=2u l=0.13u ng=1 m=1
M69 net29 X net31 pt_well sg13_lv_nmos w=1u l=0.13u ng=1 m=1
M70 net31 net27 VSS pt_well sg13_lv_nmos w=1u l=0.13u ng=1 m=1
M71 net28 net29 Vout_2 well sg13_lv_pmos w=2u l=0.13u ng=1 m=1
M72 net28 net29 VSS pt_well sg13_lv_nmos w=1u l=0.13u ng=1 m=1
M73 net30 Y Vout_2 well sg13_lv_pmos w=2u l=0.13u ng=1 m=1
M74 net30 Y VSS pt_well sg13_lv_nmos w=1u l=0.13u ng=1 m=1
M75 net32 net30 Vout_2 well sg13_lv_pmos w=2u l=0.13u ng=1 m=1
M76 S2 net27 net32 well sg13_lv_pmos w=2u l=0.13u ng=1 m=1
M77 S2 net30 VSS pt_well sg13_lv_nmos w=1u l=0.13u ng=1 m=1
M78 S2 net27 VSS pt_well sg13_lv_nmos w=1u l=0.13u ng=1 m=1
R6 Vout_2 well ntap1 A=7e-12 P=1.6e-05
M79 net33 net28 Vout_1 well_1 sg13_lv_pmos w=2u l=0.13u ng=1 m=1
M80 net33 net28 VSS pt_well sg13_lv_nmos w=1u l=0.13u ng=1 m=1
M81 S1 net33 Vout_1 well_1 sg13_lv_pmos w=2u l=0.13u ng=1 m=1
M82 S1 net33 VSS pt_well sg13_lv_nmos w=1u l=0.13u ng=1 m=1
R7 Vout_1 well_1 ntap1 A=2e-12 P=6e-06
R30 VSS pt_well ptap1 A=1.3e-11 P=2.8e-05
R32 VSS pt_well ptap1 A=1e-11 P=2.2e-05
R34 VSS pt_well ptap1 A=2.9e-11 P=6e-05
R35 VSS pt_well ptap1 A=3e-12 P=8e-06
R36 VSS pt_well ptap1 A=7e-12 P=1.6e-05
R31 VSS pt_well ptap1 A=1.3e-11 P=2.8e-05
R33 VSS pt_well ptap1 A=1e-11 P=2.2e-05
.ends
