* Extracted by KLayout with SG13G2 LVS runset on : 07/04/2026 06:19

.SUBCKT dig_control VSS Vx1 Ibias_5 Ibias_6 Vx2 VB0V4 VB0V5 Vout_2 Vout_1 S2 S1
M$1 VSS \$104 \$105 \$1 sg13_lv_nmos L=0.13u W=1u AS=0.34p AD=0.34p PS=2.68u
+ PD=2.68u
M$2 VSS \$102 S2 \$1 sg13_lv_nmos L=0.13u W=1u AS=0.34p AD=0.19p PS=2.68u
+ PD=1.38u
M$3 S2 \$106 VSS \$1 sg13_lv_nmos L=0.13u W=1u AS=0.19p AD=0.36p PS=1.38u
+ PD=2.72u
M$4 VSS \$38 \$102 \$1 sg13_lv_nmos L=0.13u W=1u AS=0.34p AD=0.34p PS=2.68u
+ PD=2.68u
M$5 VSS \$106 \$121 \$1 sg13_lv_nmos L=0.13u W=1u AS=0.34p AD=0.19p PS=2.68u
+ PD=1.38u
M$6 \$121 \$37 \$104 \$1 sg13_lv_nmos L=0.13u W=1u AS=0.19p AD=0.36p PS=1.38u
+ PD=2.72u
M$7 \$29 Ibias_6 VSS \$1 sg13_lv_nmos L=0.5u W=1u AS=0.34p AD=0.19p PS=2.68u
+ PD=1.38u
M$8 VSS Ibias_6 Ibias_6 \$1 sg13_lv_nmos L=0.5u W=1u AS=0.19p AD=0.34p PS=1.38u
+ PD=2.68u
M$9 VSS \$9 \$9 \$1 sg13_lv_nmos L=0.5u W=1u AS=0.34p AD=0.34p PS=2.68u PD=2.68u
M$10 \$30 \$9 VSS \$1 sg13_lv_nmos L=0.5u W=1u AS=0.34p AD=0.34p PS=2.68u
+ PD=2.68u
M$11 VSS \$6 \$26 \$1 sg13_lv_nmos L=0.5u W=1u AS=0.34p AD=0.34p PS=2.68u
+ PD=2.68u
M$12 Ibias_5 Ibias_5 VSS \$1 sg13_lv_nmos L=0.5u W=1u AS=0.34p AD=0.19p
+ PS=2.68u PD=1.38u
M$13 VSS Ibias_5 \$23 \$1 sg13_lv_nmos L=0.5u W=1u AS=0.19p AD=0.34p PS=1.38u
+ PD=2.68u
M$14 \$6 \$6 VSS \$1 sg13_lv_nmos L=0.5u W=1u AS=0.34p AD=0.34p PS=2.68u
+ PD=2.68u
M$15 \$49 Vx2 \$29 \$1 sg13_lv_nmos L=0.5u W=5u AS=1.7p AD=0.95p PS=10.68u
+ PD=5.38u
M$16 \$29 VB0V5 \$53 \$1 sg13_lv_nmos L=0.5u W=5u AS=0.95p AD=1.7p PS=5.38u
+ PD=10.68u
M$17 \$47 VB0V4 \$23 \$1 sg13_lv_nmos L=0.5u W=5u AS=1.7p AD=0.95p PS=10.68u
+ PD=5.38u
M$18 \$23 Vx1 \$54 \$1 sg13_lv_nmos L=0.5u W=5u AS=0.95p AD=1.7p PS=5.38u
+ PD=10.68u
M$19 Vout_2 \$104 \$105 \$101 sg13_lv_pmos L=0.13u W=2u AS=0.68p AD=0.68p
+ PS=4.68u PD=4.68u
M$20 Vout_2 \$106 \$104 \$101 sg13_lv_pmos L=0.13u W=2u AS=0.68p AD=0.38p
+ PS=4.68u PD=2.38u
M$21 \$104 \$37 Vout_2 \$101 sg13_lv_pmos L=0.13u W=2u AS=0.38p AD=0.72p
+ PS=2.38u PD=4.72u
M$22 Vout_2 \$102 \$118 \$101 sg13_lv_pmos L=0.13u W=2u AS=0.68p AD=0.38p
+ PS=4.68u PD=2.38u
M$23 \$118 \$106 S2 \$101 sg13_lv_pmos L=0.13u W=2u AS=0.38p AD=0.72p PS=2.38u
+ PD=4.72u
M$24 Vout_2 \$38 \$102 \$101 sg13_lv_pmos L=0.13u W=2u AS=0.68p AD=0.68p
+ PS=4.68u PD=4.68u
M$25 \$53 \$53 Vout_2 \$46 sg13_lv_pmos L=0.13u W=0.5u AS=0.17p AD=0.17p
+ PS=1.68u PD=1.68u
M$26 Vout_2 \$47 \$47 \$46 sg13_lv_pmos L=0.13u W=0.5u AS=0.17p AD=0.17p
+ PS=1.68u PD=1.68u
M$27 \$54 \$47 Vout_2 \$46 sg13_lv_pmos L=0.13u W=0.5u AS=0.17p AD=0.095p
+ PS=1.68u PD=0.88u
M$28 Vout_2 \$54 \$47 \$46 sg13_lv_pmos L=0.13u W=0.5u AS=0.095p AD=0.17p
+ PS=0.88u PD=1.68u
M$29 \$54 \$54 Vout_2 \$46 sg13_lv_pmos L=0.13u W=0.5u AS=0.17p AD=0.17p
+ PS=1.68u PD=1.68u
M$30 \$53 \$49 Vout_2 \$46 sg13_lv_pmos L=0.13u W=0.5u AS=0.17p AD=0.095p
+ PS=1.68u PD=0.88u
M$31 Vout_2 \$53 \$49 \$46 sg13_lv_pmos L=0.13u W=0.5u AS=0.095p AD=0.17p
+ PS=0.88u PD=1.68u
M$32 Vout_2 \$49 \$49 \$46 sg13_lv_pmos L=0.13u W=0.5u AS=0.17p AD=0.17p
+ PS=1.68u PD=1.68u
R$33 \$112 Vout_1 ntap1 A=2p P=6u
R$34 \$3 Vout_1 ntap1 A=10p P=22u
R$35 \$13 Vout_2 ntap1 A=10p P=22u
R$36 \$101 Vout_2 ntap1 A=36p P=76u
R$38 \$46 Vout_2 ntap1 A=24p P=52u
R$40 \$1 VSS ptap1 A=85p P=184u
M$44 VSS \$36 \$37 \$1 sg13_lv_nmos L=0.13u W=3u AS=1.02p AD=1.02p PS=6.68u
+ PD=6.68u
M$45 VSS \$39 \$38 \$1 sg13_lv_nmos L=0.13u W=3u AS=1.02p AD=1.02p PS=6.68u
+ PD=6.68u
M$46 Vout_2 \$39 \$38 \$46 sg13_lv_pmos L=0.13u W=6u AS=2.04p AD=2.04p
+ PS=13.36u PD=13.36u
M$48 Vout_2 \$36 \$37 \$46 sg13_lv_pmos L=0.13u W=6u AS=2.04p AD=2.04p
+ PS=13.36u PD=13.36u
M$50 VSS Vx1 Vx1 \$1 sg13_lv_nmos L=10u W=0.5u AS=0.17p AD=0.17p PS=1.68u
+ PD=1.68u
M$51 VSS Vx2 Vx2 \$1 sg13_lv_nmos L=10u W=0.5u AS=0.17p AD=0.17p PS=1.68u
+ PD=1.68u
M$52 Vout_2 \$30 \$40 \$46 sg13_lv_pmos L=0.13u W=2u AS=0.68p AD=0.68p PS=5.36u
+ PD=5.36u
M$54 Vout_2 \$26 \$35 \$46 sg13_lv_pmos L=0.13u W=2u AS=0.68p AD=0.68p PS=5.36u
+ PD=5.36u
M$56 Vout_2 \$47 \$6 \$46 sg13_lv_pmos L=0.5u W=2u AS=0.68p AD=0.68p PS=4.68u
+ PD=4.68u
M$57 Vout_2 \$53 \$9 \$46 sg13_lv_pmos L=0.5u W=2u AS=0.68p AD=0.68p PS=4.68u
+ PD=4.68u
M$58 \$30 \$49 Vout_2 \$46 sg13_lv_pmos L=0.5u W=2u AS=0.68p AD=0.68p PS=4.68u
+ PD=4.68u
M$59 \$26 \$54 Vout_2 \$46 sg13_lv_pmos L=0.5u W=2u AS=0.68p AD=0.68p PS=4.68u
+ PD=4.68u
M$62 Vout_2 \$88 \$100 \$101 sg13_lv_pmos L=0.13u W=4u AS=1.36p AD=1.36p
+ PS=8.68u PD=8.68u
M$63 VSS \$35 \$36 \$1 sg13_lv_nmos L=0.13u W=2u AS=0.68p AD=0.68p PS=4.68u
+ PD=4.68u
M$64 VSS \$40 \$39 \$1 sg13_lv_nmos L=0.13u W=2u AS=0.68p AD=0.68p PS=4.68u
+ PD=4.68u
M$65 VSS \$88 \$100 \$1 sg13_lv_nmos L=0.13u W=2u AS=0.68p AD=0.68p PS=4.68u
+ PD=4.68u
M$66 \$106 \$100 Vout_2 \$101 sg13_lv_pmos L=0.13u W=8u AS=2.12p AD=2.12p
+ PS=13.06u PD=13.06u
M$68 VSS \$100 \$106 \$1 sg13_lv_nmos L=0.13u W=4u AS=1.06p AD=1.06p PS=7.06u
+ PD=7.06u
M$70 VSS \$26 \$35 \$1 sg13_lv_nmos L=0.13u W=1u AS=0.34p AD=0.34p PS=2.68u
+ PD=2.68u
M$71 VSS \$30 \$40 \$1 sg13_lv_nmos L=0.13u W=1u AS=0.34p AD=0.34p PS=2.68u
+ PD=2.68u
M$72 VSS \$113 S1 \$1 sg13_lv_nmos L=0.13u W=1u AS=0.34p AD=0.34p PS=2.68u
+ PD=2.68u
M$73 VSS \$105 \$113 \$1 sg13_lv_nmos L=0.13u W=1u AS=0.34p AD=0.34p PS=2.68u
+ PD=2.68u
M$74 Vout_2 \$40 \$39 \$46 sg13_lv_pmos L=0.13u W=4u AS=1.36p AD=1.36p PS=9.36u
+ PD=9.36u
M$76 Vout_2 \$35 \$36 \$46 sg13_lv_pmos L=0.13u W=4u AS=1.36p AD=1.36p PS=9.36u
+ PD=9.36u
M$78 Vout_1 \$113 S1 \$112 sg13_lv_pmos L=0.13u W=2u AS=0.68p AD=0.68p PS=4.68u
+ PD=4.68u
M$79 Vout_1 \$105 \$113 \$112 sg13_lv_pmos L=0.13u W=2u AS=0.68p AD=0.68p
+ PS=4.68u PD=4.68u
M$81 Vout_2 \$88 \$89 \$101 sg13_lv_pmos L=1u W=4u AS=1.36p AD=1.36p PS=8.68u
+ PD=8.68u
M$82 Vout_2 \$89 \$90 \$101 sg13_lv_pmos L=1u W=4u AS=1.36p AD=1.36p PS=8.68u
+ PD=8.68u
M$83 Vout_2 \$90 \$91 \$101 sg13_lv_pmos L=1u W=4u AS=1.36p AD=1.36p PS=8.68u
+ PD=8.68u
M$84 Vout_2 \$91 \$92 \$101 sg13_lv_pmos L=1u W=4u AS=1.36p AD=1.36p PS=8.68u
+ PD=8.68u
M$85 Vout_2 \$92 \$93 \$101 sg13_lv_pmos L=1u W=4u AS=1.36p AD=1.36p PS=8.68u
+ PD=8.68u
M$86 Vout_2 \$93 \$94 \$101 sg13_lv_pmos L=1u W=4u AS=1.36p AD=1.36p PS=8.68u
+ PD=8.68u
M$87 Vout_2 \$94 \$95 \$101 sg13_lv_pmos L=1u W=4u AS=1.36p AD=1.36p PS=8.68u
+ PD=8.68u
M$88 Vout_2 \$95 \$96 \$101 sg13_lv_pmos L=1u W=4u AS=1.36p AD=1.36p PS=8.68u
+ PD=8.68u
M$89 Vout_2 \$96 \$97 \$101 sg13_lv_pmos L=1u W=4u AS=1.36p AD=1.36p PS=8.68u
+ PD=8.68u
M$90 Vout_2 \$97 \$98 \$101 sg13_lv_pmos L=1u W=4u AS=1.36p AD=1.36p PS=8.68u
+ PD=8.68u
M$91 Vout_2 \$98 \$88 \$101 sg13_lv_pmos L=1u W=4u AS=1.36p AD=1.36p PS=8.68u
+ PD=8.68u
M$92 VSS \$95 \$96 \$1 sg13_lv_nmos L=1u W=2u AS=0.68p AD=0.68p PS=4.68u
+ PD=4.68u
M$93 VSS \$97 \$98 \$1 sg13_lv_nmos L=1u W=2u AS=0.68p AD=0.68p PS=4.68u
+ PD=4.68u
M$94 VSS \$90 \$91 \$1 sg13_lv_nmos L=1u W=2u AS=0.68p AD=0.68p PS=4.68u
+ PD=4.68u
M$95 VSS \$91 \$92 \$1 sg13_lv_nmos L=1u W=2u AS=0.68p AD=0.68p PS=4.68u
+ PD=4.68u
M$96 VSS \$96 \$97 \$1 sg13_lv_nmos L=1u W=2u AS=0.68p AD=0.68p PS=4.68u
+ PD=4.68u
M$97 VSS \$89 \$90 \$1 sg13_lv_nmos L=1u W=2u AS=0.68p AD=0.68p PS=4.68u
+ PD=4.68u
M$98 VSS \$93 \$94 \$1 sg13_lv_nmos L=1u W=2u AS=0.68p AD=0.68p PS=4.68u
+ PD=4.68u
M$99 VSS \$94 \$95 \$1 sg13_lv_nmos L=1u W=2u AS=0.68p AD=0.68p PS=4.68u
+ PD=4.68u
M$100 VSS \$88 \$89 \$1 sg13_lv_nmos L=1u W=2u AS=0.68p AD=0.68p PS=4.68u
+ PD=4.68u
M$101 VSS \$92 \$93 \$1 sg13_lv_nmos L=1u W=2u AS=0.68p AD=0.68p PS=4.68u
+ PD=4.68u
M$102 VSS \$98 \$88 \$1 sg13_lv_nmos L=1u W=2u AS=0.68p AD=0.68p PS=4.68u
+ PD=4.68u
M$103 Vout_2 Vx2 Vx2 \$13 sg13_lv_pmos L=10u W=5u AS=1.7p AD=1.7p PS=16.8u
+ PD=16.8u
M$113 Vout_1 Vx1 Vx1 \$3 sg13_lv_pmos L=10u W=9.5u AS=3.23p AD=3.23p PS=31.92u
+ PD=31.92u
.ENDS dig_control
